* NGSPICE file created from compute_core.ext - technology: sky130A

* Black-box entry subcircuit for sky130_ef_sc_hd__decap_12 abstract view
.subckt sky130_ef_sc_hd__decap_12 VPWR VGND VPB VNB
.ends

* Black-box entry subcircuit for sky130_fd_sc_hd__fill_1 abstract view
.subckt sky130_fd_sc_hd__fill_1 VGND VNB VPB VPWR
.ends

* Black-box entry subcircuit for sky130_fd_sc_hd__dfxtp_1 abstract view
.subckt sky130_fd_sc_hd__dfxtp_1 CLK D VGND VNB VPB VPWR Q
.ends

* Black-box entry subcircuit for sky130_fd_sc_hd__tapvpwrvgnd_1 abstract view
.subckt sky130_fd_sc_hd__tapvpwrvgnd_1 VGND VPWR
.ends

* Black-box entry subcircuit for sky130_fd_sc_hd__fill_2 abstract view
.subckt sky130_fd_sc_hd__fill_2 VGND VNB VPB VPWR
.ends

* Black-box entry subcircuit for sky130_fd_sc_hd__dlymetal6s2s_1 abstract view
.subckt sky130_fd_sc_hd__dlymetal6s2s_1 A VGND VNB VPB VPWR X
.ends

* Black-box entry subcircuit for sky130_fd_sc_hd__decap_3 abstract view
.subckt sky130_fd_sc_hd__decap_3 VGND VNB VPB VPWR
.ends

* Black-box entry subcircuit for sky130_fd_sc_hd__a211oi_2 abstract view
.subckt sky130_fd_sc_hd__a211oi_2 A1 A2 B1 C1 VGND VNB VPB VPWR Y
.ends

* Black-box entry subcircuit for sky130_fd_sc_hd__and3_1 abstract view
.subckt sky130_fd_sc_hd__and3_1 A B C VGND VNB VPB VPWR X
.ends

* Black-box entry subcircuit for sky130_fd_sc_hd__nor3_1 abstract view
.subckt sky130_fd_sc_hd__nor3_1 A B C VGND VNB VPB VPWR Y
.ends

* Black-box entry subcircuit for sky130_fd_sc_hd__or3_4 abstract view
.subckt sky130_fd_sc_hd__or3_4 A B C VGND VNB VPB VPWR X
.ends

* Black-box entry subcircuit for sky130_fd_sc_hd__buf_2 abstract view
.subckt sky130_fd_sc_hd__buf_2 A VGND VNB VPB VPWR X
.ends

* Black-box entry subcircuit for sky130_fd_sc_hd__buf_1 abstract view
.subckt sky130_fd_sc_hd__buf_1 A VGND VNB VPB VPWR X
.ends

* Black-box entry subcircuit for sky130_fd_sc_hd__a21o_1 abstract view
.subckt sky130_fd_sc_hd__a21o_1 A1 A2 B1 VGND VNB VPB VPWR X
.ends

* Black-box entry subcircuit for sky130_fd_sc_hd__or2_1 abstract view
.subckt sky130_fd_sc_hd__or2_1 A B VGND VNB VPB VPWR X
.ends

* Black-box entry subcircuit for sky130_fd_sc_hd__nand2_1 abstract view
.subckt sky130_fd_sc_hd__nand2_1 A B VGND VNB VPB VPWR Y
.ends

* Black-box entry subcircuit for sky130_fd_sc_hd__xnor2_1 abstract view
.subckt sky130_fd_sc_hd__xnor2_1 A B VGND VNB VPB VPWR Y
.ends

* Black-box entry subcircuit for sky130_fd_sc_hd__decap_8 abstract view
.subckt sky130_fd_sc_hd__decap_8 VGND VNB VPB VPWR
.ends

* Black-box entry subcircuit for sky130_fd_sc_hd__decap_4 abstract view
.subckt sky130_fd_sc_hd__decap_4 VGND VNB VPB VPWR
.ends

* Black-box entry subcircuit for sky130_fd_sc_hd__nor2_1 abstract view
.subckt sky130_fd_sc_hd__nor2_1 A B VGND VNB VPB VPWR Y
.ends

* Black-box entry subcircuit for sky130_fd_sc_hd__xnor2_2 abstract view
.subckt sky130_fd_sc_hd__xnor2_2 A B VGND VNB VPB VPWR Y
.ends

* Black-box entry subcircuit for sky130_fd_sc_hd__nand3_1 abstract view
.subckt sky130_fd_sc_hd__nand3_1 A B C VGND VNB VPB VPWR Y
.ends

* Black-box entry subcircuit for sky130_fd_sc_hd__a21oi_1 abstract view
.subckt sky130_fd_sc_hd__a21oi_1 A1 A2 B1 VGND VNB VPB VPWR Y
.ends

* Black-box entry subcircuit for sky130_fd_sc_hd__o211a_1 abstract view
.subckt sky130_fd_sc_hd__o211a_1 A1 A2 B1 C1 VGND VNB VPB VPWR X
.ends

* Black-box entry subcircuit for sky130_fd_sc_hd__and2b_1 abstract view
.subckt sky130_fd_sc_hd__and2b_1 A_N B VGND VNB VPB VPWR X
.ends

* Black-box entry subcircuit for sky130_fd_sc_hd__dlygate4sd3_1 abstract view
.subckt sky130_fd_sc_hd__dlygate4sd3_1 A VGND VNB VPB VPWR X
.ends

* Black-box entry subcircuit for sky130_fd_sc_hd__dlygate4sd1_1 abstract view
.subckt sky130_fd_sc_hd__dlygate4sd1_1 A VGND VNB VPB VPWR X
.ends

* Black-box entry subcircuit for sky130_fd_sc_hd__inv_2 abstract view
.subckt sky130_fd_sc_hd__inv_2 A VGND VNB VPB VPWR Y
.ends

* Black-box entry subcircuit for sky130_fd_sc_hd__o211ai_1 abstract view
.subckt sky130_fd_sc_hd__o211ai_1 A1 A2 B1 C1 VGND VNB VPB VPWR Y
.ends

* Black-box entry subcircuit for sky130_fd_sc_hd__decap_6 abstract view
.subckt sky130_fd_sc_hd__decap_6 VGND VNB VPB VPWR
.ends

* Black-box entry subcircuit for sky130_fd_sc_hd__and2_1 abstract view
.subckt sky130_fd_sc_hd__and2_1 A B VGND VNB VPB VPWR X
.ends

* Black-box entry subcircuit for sky130_fd_sc_hd__a21bo_1 abstract view
.subckt sky130_fd_sc_hd__a21bo_1 A1 A2 B1_N VGND VNB VPB VPWR X
.ends

* Black-box entry subcircuit for sky130_fd_sc_hd__o21a_1 abstract view
.subckt sky130_fd_sc_hd__o21a_1 A1 A2 B1 VGND VNB VPB VPWR X
.ends

* Black-box entry subcircuit for sky130_fd_sc_hd__o21bai_1 abstract view
.subckt sky130_fd_sc_hd__o21bai_1 A1 A2 B1_N VGND VNB VPB VPWR Y
.ends

* Black-box entry subcircuit for sky130_fd_sc_hd__and4_1 abstract view
.subckt sky130_fd_sc_hd__and4_1 A B C D VGND VNB VPB VPWR X
.ends

* Black-box entry subcircuit for sky130_fd_sc_hd__buf_4 abstract view
.subckt sky130_fd_sc_hd__buf_4 A VGND VNB VPB VPWR X
.ends

* Black-box entry subcircuit for sky130_fd_sc_hd__and3_4 abstract view
.subckt sky130_fd_sc_hd__and3_4 A B C VGND VNB VPB VPWR X
.ends

* Black-box entry subcircuit for sky130_fd_sc_hd__clkbuf_2 abstract view
.subckt sky130_fd_sc_hd__clkbuf_2 A VGND VNB VPB VPWR X
.ends

* Black-box entry subcircuit for sky130_fd_sc_hd__a21oi_2 abstract view
.subckt sky130_fd_sc_hd__a21oi_2 A1 A2 B1 VGND VNB VPB VPWR Y
.ends

* Black-box entry subcircuit for sky130_fd_sc_hd__a22o_1 abstract view
.subckt sky130_fd_sc_hd__a22o_1 A1 A2 B1 B2 VGND VNB VPB VPWR X
.ends

* Black-box entry subcircuit for sky130_fd_sc_hd__a211o_1 abstract view
.subckt sky130_fd_sc_hd__a211o_1 A1 A2 B1 C1 VGND VNB VPB VPWR X
.ends

* Black-box entry subcircuit for sky130_fd_sc_hd__mux2_1 abstract view
.subckt sky130_fd_sc_hd__mux2_1 A0 A1 S VGND VNB VPB VPWR X
.ends

* Black-box entry subcircuit for sky130_fd_sc_hd__o221a_1 abstract view
.subckt sky130_fd_sc_hd__o221a_1 A1 A2 B1 B2 C1 VGND VNB VPB VPWR X
.ends

* Black-box entry subcircuit for sky130_fd_sc_hd__and2_4 abstract view
.subckt sky130_fd_sc_hd__and2_4 A B VGND VNB VPB VPWR X
.ends

* Black-box entry subcircuit for sky130_fd_sc_hd__o311ai_4 abstract view
.subckt sky130_fd_sc_hd__o311ai_4 A1 A2 A3 B1 C1 VGND VNB VPB VPWR Y
.ends

* Black-box entry subcircuit for sky130_fd_sc_hd__buf_8 abstract view
.subckt sky130_fd_sc_hd__buf_8 A VGND VNB VPB VPWR X
.ends

* Black-box entry subcircuit for sky130_fd_sc_hd__o211ai_2 abstract view
.subckt sky130_fd_sc_hd__o211ai_2 A1 A2 B1 C1 VGND VNB VPB VPWR Y
.ends

* Black-box entry subcircuit for sky130_fd_sc_hd__a22oi_1 abstract view
.subckt sky130_fd_sc_hd__a22oi_1 A1 A2 B1 B2 VGND VNB VPB VPWR Y
.ends

* Black-box entry subcircuit for sky130_fd_sc_hd__and2_2 abstract view
.subckt sky130_fd_sc_hd__and2_2 A B VGND VNB VPB VPWR X
.ends

* Black-box entry subcircuit for sky130_fd_sc_hd__a31o_1 abstract view
.subckt sky130_fd_sc_hd__a31o_1 A1 A2 A3 B1 VGND VNB VPB VPWR X
.ends

* Black-box entry subcircuit for sky130_fd_sc_hd__o21ai_1 abstract view
.subckt sky130_fd_sc_hd__o21ai_1 A1 A2 B1 VGND VNB VPB VPWR Y
.ends

* Black-box entry subcircuit for sky130_fd_sc_hd__nand2_2 abstract view
.subckt sky130_fd_sc_hd__nand2_2 A B VGND VNB VPB VPWR Y
.ends

* Black-box entry subcircuit for sky130_fd_sc_hd__or3b_4 abstract view
.subckt sky130_fd_sc_hd__or3b_4 A B C_N VGND VNB VPB VPWR X
.ends

* Black-box entry subcircuit for sky130_fd_sc_hd__or3b_1 abstract view
.subckt sky130_fd_sc_hd__or3b_1 A B C_N VGND VNB VPB VPWR X
.ends

* Black-box entry subcircuit for sky130_fd_sc_hd__a211oi_1 abstract view
.subckt sky130_fd_sc_hd__a211oi_1 A1 A2 B1 C1 VGND VNB VPB VPWR Y
.ends

* Black-box entry subcircuit for sky130_fd_sc_hd__o21ai_2 abstract view
.subckt sky130_fd_sc_hd__o21ai_2 A1 A2 B1 VGND VNB VPB VPWR Y
.ends

* Black-box entry subcircuit for sky130_fd_sc_hd__clkinv_2 abstract view
.subckt sky130_fd_sc_hd__clkinv_2 A VGND VNB VPB VPWR Y
.ends

* Black-box entry subcircuit for sky130_fd_sc_hd__or3_1 abstract view
.subckt sky130_fd_sc_hd__or3_1 A B C VGND VNB VPB VPWR X
.ends

* Black-box entry subcircuit for sky130_fd_sc_hd__o21ba_1 abstract view
.subckt sky130_fd_sc_hd__o21ba_1 A1 A2 B1_N VGND VNB VPB VPWR X
.ends

* Black-box entry subcircuit for sky130_fd_sc_hd__buf_6 abstract view
.subckt sky130_fd_sc_hd__buf_6 A VGND VNB VPB VPWR X
.ends

* Black-box entry subcircuit for sky130_fd_sc_hd__clkbuf_4 abstract view
.subckt sky130_fd_sc_hd__clkbuf_4 A VGND VNB VPB VPWR X
.ends

* Black-box entry subcircuit for sky130_fd_sc_hd__nand2b_4 abstract view
.subckt sky130_fd_sc_hd__nand2b_4 A_N B VGND VNB VPB VPWR Y
.ends

* Black-box entry subcircuit for sky130_fd_sc_hd__a21o_4 abstract view
.subckt sky130_fd_sc_hd__a21o_4 A1 A2 B1 VGND VNB VPB VPWR X
.ends

* Black-box entry subcircuit for sky130_fd_sc_hd__a211oi_4 abstract view
.subckt sky130_fd_sc_hd__a211oi_4 A1 A2 B1 C1 VGND VNB VPB VPWR Y
.ends

* Black-box entry subcircuit for sky130_fd_sc_hd__nand3b_1 abstract view
.subckt sky130_fd_sc_hd__nand3b_1 A_N B C VGND VNB VPB VPWR Y
.ends

* Black-box entry subcircuit for sky130_fd_sc_hd__nor2_2 abstract view
.subckt sky130_fd_sc_hd__nor2_2 A B VGND VNB VPB VPWR Y
.ends

* Black-box entry subcircuit for sky130_fd_sc_hd__nand2b_1 abstract view
.subckt sky130_fd_sc_hd__nand2b_1 A_N B VGND VNB VPB VPWR Y
.ends

* Black-box entry subcircuit for sky130_fd_sc_hd__clkbuf_16 abstract view
.subckt sky130_fd_sc_hd__clkbuf_16 A VGND VNB VPB VPWR X
.ends

* Black-box entry subcircuit for sky130_fd_sc_hd__a21oi_4 abstract view
.subckt sky130_fd_sc_hd__a21oi_4 A1 A2 B1 VGND VNB VPB VPWR Y
.ends

* Black-box entry subcircuit for sky130_fd_sc_hd__a2bb2o_1 abstract view
.subckt sky130_fd_sc_hd__a2bb2o_1 A1_N A2_N B1 B2 VGND VNB VPB VPWR X
.ends

* Black-box entry subcircuit for sky130_fd_sc_hd__o2bb2a_1 abstract view
.subckt sky130_fd_sc_hd__o2bb2a_1 A1_N A2_N B1 B2 VGND VNB VPB VPWR X
.ends

* Black-box entry subcircuit for sky130_fd_sc_hd__o21bai_4 abstract view
.subckt sky130_fd_sc_hd__o21bai_4 A1 A2 B1_N VGND VNB VPB VPWR Y
.ends

* Black-box entry subcircuit for sky130_fd_sc_hd__and4bb_1 abstract view
.subckt sky130_fd_sc_hd__and4bb_1 A_N B_N C D VGND VNB VPB VPWR X
.ends

* Black-box entry subcircuit for sky130_fd_sc_hd__nor3b_1 abstract view
.subckt sky130_fd_sc_hd__nor3b_1 A B C_N VGND VNB VPB VPWR Y
.ends

* Black-box entry subcircuit for sky130_fd_sc_hd__a211o_4 abstract view
.subckt sky130_fd_sc_hd__a211o_4 A1 A2 B1 C1 VGND VNB VPB VPWR X
.ends

* Black-box entry subcircuit for sky130_fd_sc_hd__xor2_1 abstract view
.subckt sky130_fd_sc_hd__xor2_1 A B VGND VNB VPB VPWR X
.ends

* Black-box entry subcircuit for sky130_fd_sc_hd__nand3_2 abstract view
.subckt sky130_fd_sc_hd__nand3_2 A B C VGND VNB VPB VPWR Y
.ends

* Black-box entry subcircuit for sky130_fd_sc_hd__or2_4 abstract view
.subckt sky130_fd_sc_hd__or2_4 A B VGND VNB VPB VPWR X
.ends

* Black-box entry subcircuit for sky130_fd_sc_hd__clkbuf_1 abstract view
.subckt sky130_fd_sc_hd__clkbuf_1 A VGND VNB VPB VPWR X
.ends

* Black-box entry subcircuit for sky130_fd_sc_hd__nor2_4 abstract view
.subckt sky130_fd_sc_hd__nor2_4 A B VGND VNB VPB VPWR Y
.ends

* Black-box entry subcircuit for sky130_fd_sc_hd__a21boi_1 abstract view
.subckt sky130_fd_sc_hd__a21boi_1 A1 A2 B1_N VGND VNB VPB VPWR Y
.ends

* Black-box entry subcircuit for sky130_fd_sc_hd__o31a_1 abstract view
.subckt sky130_fd_sc_hd__o31a_1 A1 A2 A3 B1 VGND VNB VPB VPWR X
.ends

* Black-box entry subcircuit for sky130_fd_sc_hd__and3b_1 abstract view
.subckt sky130_fd_sc_hd__and3b_1 A_N B C VGND VNB VPB VPWR X
.ends

* Black-box entry subcircuit for sky130_fd_sc_hd__o22a_4 abstract view
.subckt sky130_fd_sc_hd__o22a_4 A1 A2 B1 B2 VGND VNB VPB VPWR X
.ends

* Black-box entry subcircuit for sky130_fd_sc_hd__xor2_2 abstract view
.subckt sky130_fd_sc_hd__xor2_2 A B VGND VNB VPB VPWR X
.ends

* Black-box entry subcircuit for sky130_fd_sc_hd__nor3_2 abstract view
.subckt sky130_fd_sc_hd__nor3_2 A B C VGND VNB VPB VPWR Y
.ends

* Black-box entry subcircuit for sky130_fd_sc_hd__or4bb_4 abstract view
.subckt sky130_fd_sc_hd__or4bb_4 A B C_N D_N VGND VNB VPB VPWR X
.ends

* Black-box entry subcircuit for sky130_fd_sc_hd__nand2_4 abstract view
.subckt sky130_fd_sc_hd__nand2_4 A B VGND VNB VPB VPWR Y
.ends

* Black-box entry subcircuit for sky130_fd_sc_hd__a31oi_1 abstract view
.subckt sky130_fd_sc_hd__a31oi_1 A1 A2 A3 B1 VGND VNB VPB VPWR Y
.ends

* Black-box entry subcircuit for sky130_fd_sc_hd__o31ai_4 abstract view
.subckt sky130_fd_sc_hd__o31ai_4 A1 A2 A3 B1 VGND VNB VPB VPWR Y
.ends

* Black-box entry subcircuit for sky130_fd_sc_hd__nand4_1 abstract view
.subckt sky130_fd_sc_hd__nand4_1 A B C D VGND VNB VPB VPWR Y
.ends

* Black-box entry subcircuit for sky130_fd_sc_hd__o311a_1 abstract view
.subckt sky130_fd_sc_hd__o311a_1 A1 A2 A3 B1 C1 VGND VNB VPB VPWR X
.ends

* Black-box entry subcircuit for sky130_fd_sc_hd__a311o_1 abstract view
.subckt sky130_fd_sc_hd__a311o_1 A1 A2 A3 B1 C1 VGND VNB VPB VPWR X
.ends

* Black-box entry subcircuit for sky130_fd_sc_hd__o22a_1 abstract view
.subckt sky130_fd_sc_hd__o22a_1 A1 A2 B1 B2 VGND VNB VPB VPWR X
.ends

* Black-box entry subcircuit for sky130_fd_sc_hd__nor4_4 abstract view
.subckt sky130_fd_sc_hd__nor4_4 A B C D VGND VNB VPB VPWR Y
.ends

* Black-box entry subcircuit for sky130_fd_sc_hd__a311o_4 abstract view
.subckt sky130_fd_sc_hd__a311o_4 A1 A2 A3 B1 C1 VGND VNB VPB VPWR X
.ends

* Black-box entry subcircuit for sky130_fd_sc_hd__nand4_2 abstract view
.subckt sky130_fd_sc_hd__nand4_2 A B C D VGND VNB VPB VPWR Y
.ends

* Black-box entry subcircuit for sky130_fd_sc_hd__and2b_2 abstract view
.subckt sky130_fd_sc_hd__and2b_2 A_N B VGND VNB VPB VPWR X
.ends

* Black-box entry subcircuit for sky130_fd_sc_hd__xor2_4 abstract view
.subckt sky130_fd_sc_hd__xor2_4 A B VGND VNB VPB VPWR X
.ends

* Black-box entry subcircuit for sky130_fd_sc_hd__a32oi_2 abstract view
.subckt sky130_fd_sc_hd__a32oi_2 A1 A2 A3 B1 B2 VGND VNB VPB VPWR Y
.ends

* Black-box entry subcircuit for sky130_fd_sc_hd__dlymetal6s4s_1 abstract view
.subckt sky130_fd_sc_hd__dlymetal6s4s_1 A VGND VNB VPB VPWR X
.ends

* Black-box entry subcircuit for sky130_fd_sc_hd__xnor2_4 abstract view
.subckt sky130_fd_sc_hd__xnor2_4 A B VGND VNB VPB VPWR Y
.ends

* Black-box entry subcircuit for sky130_fd_sc_hd__and4b_1 abstract view
.subckt sky130_fd_sc_hd__and4b_1 A_N B C D VGND VNB VPB VPWR X
.ends

.subckt compute_core VGND VPWR acc_out[0] acc_out[10] acc_out[11] acc_out[12] acc_out[13]
+ acc_out[14] acc_out[15] acc_out[16] acc_out[17] acc_out[18] acc_out[19] acc_out[1]
+ acc_out[20] acc_out[21] acc_out[22] acc_out[23] acc_out[24] acc_out[25] acc_out[26]
+ acc_out[27] acc_out[28] acc_out[29] acc_out[2] acc_out[30] acc_out[31] acc_out[3]
+ acc_out[4] acc_out[5] acc_out[6] acc_out[7] acc_out[8] acc_out[9] activation[0]
+ activation[1] activation[2] activation[3] activation[4] activation[5] activation[6]
+ activation[7] clk done en rst valid_in valid_out weight[0] weight[1] weight[2] weight[3]
+ weight[4] weight[5] weight[6] weight[7]
XFILLER_39_244 VPWR VGND VPWR VGND sky130_ef_sc_hd__decap_12
XFILLER_39_211 VGND VGND VPWR VPWR sky130_fd_sc_hd__fill_1
X_2037_ clknet_2_3__leaf_clk _0028_ VGND VGND VPWR VPWR net38 sky130_fd_sc_hd__dfxtp_1
XFILLER_22_122 VGND VGND VPWR VPWR sky130_fd_sc_hd__fill_1
XTAP_TAPCELL_ROW_9_159 VGND VPWR sky130_fd_sc_hd__tapvpwrvgnd_1
XFILLER_13_111 VGND VGND VPWR VPWR sky130_fd_sc_hd__fill_1
XFILLER_42_40 VPWR VGND VPWR VGND sky130_ef_sc_hd__decap_12
XFILLER_13_177 VGND VGND VPWR VPWR sky130_fd_sc_hd__fill_2
Xrebuffer7 net131 VGND VGND VPWR VPWR net132 sky130_fd_sc_hd__dlymetal6s2s_1
XFILLER_3_23 VGND VGND VPWR VPWR sky130_fd_sc_hd__decap_3
XFILLER_36_225 VGND VGND VPWR VPWR sky130_fd_sc_hd__fill_1
XFILLER_3_67 VPWR VGND VPWR VGND sky130_ef_sc_hd__decap_12
X_1270_ _0318_ _0320_ _0363_ _0365_ VGND VGND VPWR VPWR _0366_ sky130_fd_sc_hd__a211oi_2
X_1606_ _0690_ _0689_ _0691_ VGND VGND VPWR VPWR _0693_ sky130_fd_sc_hd__and3_1
XFILLER_8_170 VGND VGND VPWR VPWR sky130_fd_sc_hd__decap_3
X_1537_ net177 _0624_ _0625_ VGND VGND VPWR VPWR _0626_ sky130_fd_sc_hd__nor3_1
X_1468_ net74 _0556_ _0557_ VGND VGND VPWR VPWR _0559_ sky130_fd_sc_hd__or3_4
Xfanout116 net123 VGND VGND VPWR VPWR net116 sky130_fd_sc_hd__buf_2
Xfanout105 net2 VGND VGND VPWR VPWR net105 sky130_fd_sc_hd__buf_1
X_1399_ _0488_ _0489_ _0490_ VGND VGND VPWR VPWR _0492_ sky130_fd_sc_hd__a21o_1
XFILLER_12_10 VPWR VGND VPWR VGND sky130_ef_sc_hd__decap_12
XFILLER_37_84 VGND VGND VPWR VPWR sky130_fd_sc_hd__fill_2
XFILLER_37_73 VGND VGND VPWR VPWR sky130_fd_sc_hd__fill_2
XTAP_TAPCELL_ROW_5_140 VGND VPWR sky130_fd_sc_hd__tapvpwrvgnd_1
XTAP_TAPCELL_ROW_28_264 VGND VPWR sky130_fd_sc_hd__tapvpwrvgnd_1
XFILLER_26_291 VGND VGND VPWR VPWR sky130_fd_sc_hd__fill_1
X_1322_ _0415_ _0416_ VGND VGND VPWR VPWR _0417_ sky130_fd_sc_hd__or2_1
X_1253_ net110 net98 VGND VGND VPWR VPWR _0349_ sky130_fd_sc_hd__nand2_1
X_1184_ _0279_ _0280_ VGND VGND VPWR VPWR _0282_ sky130_fd_sc_hd__xnor2_1
XPHY_EDGE_ROW_20_Left_72 VGND VGND VPWR VPWR sky130_fd_sc_hd__decap_3
XTAP_TAPCELL_ROW_2_121 VGND VPWR sky130_fd_sc_hd__tapvpwrvgnd_1
XFILLER_48_61 VGND VGND VPWR VPWR sky130_fd_sc_hd__fill_1
XFILLER_2_176 VPWR VGND VPWR VGND sky130_ef_sc_hd__decap_12
XFILLER_2_110 VGND VGND VPWR VPWR sky130_fd_sc_hd__decap_8
XFILLER_0_35 VPWR VGND VPWR VGND sky130_ef_sc_hd__decap_12
XFILLER_0_57 VGND VGND VPWR VPWR sky130_fd_sc_hd__fill_1
XFILLER_0_68 VGND VGND VPWR VPWR sky130_fd_sc_hd__decap_4
XTAP_TAPCELL_ROW_16_201 VGND VPWR sky130_fd_sc_hd__tapvpwrvgnd_1
X_1871_ _0953_ _0955_ VGND VGND VPWR VPWR _0956_ sky130_fd_sc_hd__nor2_1
X_1940_ net41 _0262_ VGND VGND VPWR VPWR _0059_ sky130_fd_sc_hd__nor2_1
XFILLER_50_3 VPWR VGND VPWR VGND sky130_ef_sc_hd__decap_12
XTAP_TAPCELL_ROW_39_326 VGND VPWR sky130_fd_sc_hd__tapvpwrvgnd_1
X_1236_ _0284_ _0331_ VGND VGND VPWR VPWR _0333_ sky130_fd_sc_hd__or2_1
X_1305_ _0397_ _0398_ _0391_ VGND VGND VPWR VPWR _0400_ sky130_fd_sc_hd__a21o_1
XTAP_TAPCELL_ROW_47_370 VGND VPWR sky130_fd_sc_hd__tapvpwrvgnd_1
X_1167_ net49 net19 VGND VGND VPWR VPWR _0265_ sky130_fd_sc_hd__xnor2_2
X_1098_ _0191_ _0192_ _0197_ VGND VGND VPWR VPWR _0198_ sky130_fd_sc_hd__nand3_1
XFILLER_20_253 VPWR VGND VPWR VGND sky130_ef_sc_hd__decap_12
XFILLER_18_53 VGND VGND VPWR VPWR sky130_fd_sc_hd__fill_1
XFILLER_11_231 VGND VGND VPWR VPWR sky130_fd_sc_hd__fill_1
XFILLER_50_73 VGND VGND VPWR VPWR sky130_fd_sc_hd__fill_2
XFILLER_7_279 VGND VGND VPWR VPWR sky130_fd_sc_hd__fill_1
XTAP_TAPCELL_ROW_44_351 VGND VPWR sky130_fd_sc_hd__tapvpwrvgnd_1
XTAP_TAPCELL_ROW_36_307 VGND VPWR sky130_fd_sc_hd__tapvpwrvgnd_1
X_1021_ net117 net103 net42 VGND VGND VPWR VPWR _0076_ sky130_fd_sc_hd__a21oi_1
X_1785_ _0800_ _0830_ _0862_ _0829_ VGND VGND VPWR VPWR _0866_ sky130_fd_sc_hd__o211a_1
X_1854_ _0936_ _0937_ VGND VGND VPWR VPWR _0938_ sky130_fd_sc_hd__nor2_1
X_1923_ _0040_ _0039_ VGND VGND VPWR VPWR _0041_ sky130_fd_sc_hd__and2b_1
XFILLER_44_109 VPWR VGND VPWR VGND sky130_ef_sc_hd__decap_12
XFILLER_37_150 VGND VGND VPWR VPWR sky130_fd_sc_hd__fill_2
X_1219_ _0313_ _0314_ _0305_ VGND VGND VPWR VPWR _0316_ sky130_fd_sc_hd__a21o_1
XTAP_TAPCELL_ROW_50_387 VGND VPWR sky130_fd_sc_hd__tapvpwrvgnd_1
XFILLER_20_32 VPWR VGND VPWR VGND sky130_ef_sc_hd__decap_12
XFILLER_29_85 VGND VGND VPWR VPWR sky130_fd_sc_hd__fill_2
Xhold74 net42 VGND VGND VPWR VPWR net199 sky130_fd_sc_hd__dlygate4sd3_1
XPHY_EDGE_ROW_51_Left_103 VGND VGND VPWR VPWR sky130_fd_sc_hd__decap_3
XFILLER_45_51 VGND VGND VPWR VPWR sky130_fd_sc_hd__decap_4
XFILLER_43_186 VGND VGND VPWR VPWR sky130_fd_sc_hd__decap_4
XFILLER_43_197 VPWR VGND VPWR VGND sky130_ef_sc_hd__decap_12
X_1570_ _0624_ _0626_ _0655_ _0656_ VGND VGND VPWR VPWR _0658_ sky130_fd_sc_hd__o211a_1
XFILLER_3_293 VPWR VGND VPWR VGND sky130_ef_sc_hd__decap_12
Xrebuffer39 _0735_ VGND VGND VPWR VPWR net164 sky130_fd_sc_hd__dlygate4sd1_1
Xrebuffer17 net141 VGND VGND VPWR VPWR net142 sky130_fd_sc_hd__dlygate4sd1_1
X_1004_ net19 VGND VGND VPWR VPWR _0868_ sky130_fd_sc_hd__inv_2
X_1768_ _0588_ _0848_ _0849_ VGND VGND VPWR VPWR _0850_ sky130_fd_sc_hd__nand3_1
X_1837_ net63 _0889_ _0888_ VGND VGND VPWR VPWR _0921_ sky130_fd_sc_hd__a21oi_1
X_1906_ _0990_ _0991_ VGND VGND VPWR VPWR _0992_ sky130_fd_sc_hd__nor2_1
X_1699_ _0743_ _0745_ _0779_ _0780_ VGND VGND VPWR VPWR _0783_ sky130_fd_sc_hd__o211ai_1
XFILLER_1_219 VGND VGND VPWR VPWR sky130_fd_sc_hd__decap_4
XFILLER_25_175 VGND VGND VPWR VPWR sky130_fd_sc_hd__decap_6
XFILLER_40_167 VGND VGND VPWR VPWR sky130_fd_sc_hd__decap_3
XFILLER_40_145 VGND VGND VPWR VPWR sky130_fd_sc_hd__fill_1
Xoutput53 net53 VGND VGND VPWR VPWR valid_out sky130_fd_sc_hd__buf_2
Xoutput31 net31 VGND VGND VPWR VPWR acc_out[1] sky130_fd_sc_hd__buf_2
Xoutput42 net42 VGND VGND VPWR VPWR acc_out[2] sky130_fd_sc_hd__buf_2
Xoutput20 net20 VGND VGND VPWR VPWR acc_out[0] sky130_fd_sc_hd__buf_2
XFILLER_48_289 VPWR VGND VPWR VGND sky130_ef_sc_hd__decap_12
XFILLER_31_145 VGND VGND VPWR VPWR sky130_fd_sc_hd__decap_8
XFILLER_31_123 VGND VGND VPWR VPWR sky130_fd_sc_hd__fill_1
XFILLER_16_164 VPWR VGND VPWR VGND sky130_ef_sc_hd__decap_12
XFILLER_16_186 VGND VGND VPWR VPWR sky130_fd_sc_hd__fill_1
X_1622_ _0649_ _0677_ VGND VGND VPWR VPWR _0709_ sky130_fd_sc_hd__nor2_1
X_1553_ net56 _0640_ _0641_ VGND VGND VPWR VPWR _0642_ sky130_fd_sc_hd__or3_4
X_1484_ _0572_ _0573_ _0549_ VGND VGND VPWR VPWR _0575_ sky130_fd_sc_hd__a21o_1
XFILLER_39_256 VPWR VGND VPWR VGND sky130_ef_sc_hd__decap_12
X_2036_ clknet_2_3__leaf_clk _0027_ VGND VGND VPWR VPWR net37 sky130_fd_sc_hd__dfxtp_1
XFILLER_10_307 VGND VGND VPWR VPWR sky130_fd_sc_hd__fill_1
XFILLER_13_134 VPWR VGND VPWR VGND sky130_ef_sc_hd__decap_12
XFILLER_13_167 VGND VGND VPWR VPWR sky130_fd_sc_hd__fill_1
XFILLER_42_85 VGND VGND VPWR VPWR sky130_fd_sc_hd__decap_6
XFILLER_42_52 VPWR VGND VPWR VGND sky130_ef_sc_hd__decap_12
Xrebuffer8 net132 VGND VGND VPWR VPWR net133 sky130_fd_sc_hd__dlymetal6s2s_1
XFILLER_3_79 VGND VGND VPWR VPWR sky130_fd_sc_hd__fill_2
X_1605_ _0689_ _0690_ _0691_ VGND VGND VPWR VPWR _0692_ sky130_fd_sc_hd__a21oi_1
X_1536_ net120 net93 net27 VGND VGND VPWR VPWR _0625_ sky130_fd_sc_hd__a21oi_1
XFILLER_47_19 VPWR VGND VPWR VGND sky130_ef_sc_hd__decap_12
X_1467_ net177 _0556_ _0557_ VGND VGND VPWR VPWR _0558_ sky130_fd_sc_hd__nor3_1
Xfanout117 net123 VGND VGND VPWR VPWR net117 sky130_fd_sc_hd__buf_1
Xfanout106 net18 VGND VGND VPWR VPWR net106 sky130_fd_sc_hd__buf_2
X_1398_ _0488_ _0489_ _0490_ VGND VGND VPWR VPWR _0491_ sky130_fd_sc_hd__and3_1
XFILLER_35_292 VGND VGND VPWR VPWR sky130_fd_sc_hd__fill_1
X_2019_ clknet_2_2__leaf_clk _0010_ VGND VGND VPWR VPWR net50 sky130_fd_sc_hd__dfxtp_1
XFILLER_10_126 VPWR VGND VPWR VGND sky130_ef_sc_hd__decap_12
XFILLER_12_22 VGND VGND VPWR VPWR sky130_fd_sc_hd__decap_6
XFILLER_12_88 VPWR VGND VPWR VGND sky130_ef_sc_hd__decap_12
XTAP_TAPCELL_ROW_28_265 VGND VPWR sky130_fd_sc_hd__tapvpwrvgnd_1
XTAP_TAPCELL_ROW_5_141 VGND VPWR sky130_fd_sc_hd__tapvpwrvgnd_1
X_1321_ _0370_ _0414_ VGND VGND VPWR VPWR _0416_ sky130_fd_sc_hd__and2_1
X_1252_ net96 net129 _0347_ VGND VGND VPWR VPWR _0348_ sky130_fd_sc_hd__a21bo_1
X_1183_ _0279_ _0280_ VGND VGND VPWR VPWR _0281_ sky130_fd_sc_hd__or2_1
XFILLER_17_281 VGND VGND VPWR VPWR sky130_fd_sc_hd__decap_4
XFILLER_32_251 VGND VGND VPWR VPWR sky130_fd_sc_hd__fill_1
X_1519_ _0606_ _0607_ _0587_ VGND VGND VPWR VPWR _0609_ sky130_fd_sc_hd__a21oi_1
XPHY_EDGE_ROW_12_Right_12 VGND VGND VPWR VPWR sky130_fd_sc_hd__decap_3
XTAP_TAPCELL_ROW_2_122 VGND VPWR sky130_fd_sc_hd__tapvpwrvgnd_1
XPHY_EDGE_ROW_21_Right_21 VGND VGND VPWR VPWR sky130_fd_sc_hd__decap_3
XFILLER_15_229 VGND VGND VPWR VPWR sky130_fd_sc_hd__decap_8
XPHY_EDGE_ROW_30_Right_30 VGND VGND VPWR VPWR sky130_fd_sc_hd__decap_3
XFILLER_2_188 VGND VGND VPWR VPWR sky130_fd_sc_hd__decap_8
XFILLER_0_47 VGND VGND VPWR VPWR sky130_fd_sc_hd__decap_4
XTAP_TAPCELL_ROW_16_202 VGND VPWR sky130_fd_sc_hd__tapvpwrvgnd_1
X_1870_ _0893_ _0924_ _0954_ VGND VGND VPWR VPWR _0955_ sky130_fd_sc_hd__o21a_1
XFILLER_14_251 VGND VGND VPWR VPWR sky130_fd_sc_hd__fill_1
XFILLER_43_3 VGND VGND VPWR VPWR sky130_fd_sc_hd__fill_1
XTAP_TAPCELL_ROW_39_327 VGND VPWR sky130_fd_sc_hd__tapvpwrvgnd_1
X_1235_ _0284_ _0331_ VGND VGND VPWR VPWR _0332_ sky130_fd_sc_hd__nand2_1
X_1166_ net49 net19 VGND VGND VPWR VPWR _0264_ sky130_fd_sc_hd__nand2_1
X_1304_ _0391_ _0397_ _0398_ VGND VGND VPWR VPWR _0399_ sky130_fd_sc_hd__nand3_1
XTAP_TAPCELL_ROW_47_371 VGND VPWR sky130_fd_sc_hd__tapvpwrvgnd_1
X_1097_ _0193_ _0196_ VGND VGND VPWR VPWR _0197_ sky130_fd_sc_hd__xnor2_1
XFILLER_20_232 VGND VGND VPWR VPWR sky130_fd_sc_hd__decap_6
X_1999_ _0119_ _0120_ VGND VGND VPWR VPWR _0121_ sky130_fd_sc_hd__xnor2_1
XFILLER_20_265 VGND VGND VPWR VPWR sky130_fd_sc_hd__fill_2
XFILLER_47_118 VGND VGND VPWR VPWR sky130_fd_sc_hd__decap_4
XFILLER_18_43 VGND VGND VPWR VPWR sky130_fd_sc_hd__decap_3
XFILLER_50_41 VPWR VGND VPWR VGND sky130_ef_sc_hd__decap_12
XFILLER_7_225 VPWR VGND VPWR VGND sky130_ef_sc_hd__decap_12
XTAP_TAPCELL_ROW_36_308 VGND VPWR sky130_fd_sc_hd__tapvpwrvgnd_1
XFILLER_15_7 VGND VGND VPWR VPWR sky130_fd_sc_hd__fill_1
X_1020_ net197 net82 _0056_ net86 VGND VGND VPWR VPWR _0003_ sky130_fd_sc_hd__o211a_1
XTAP_TAPCELL_ROW_44_352 VGND VPWR sky130_fd_sc_hd__tapvpwrvgnd_1
X_1922_ net63 _0977_ _0976_ VGND VGND VPWR VPWR _0040_ sky130_fd_sc_hd__a21oi_1
X_1853_ net142 _0907_ _0908_ VGND VGND VPWR VPWR _0937_ sky130_fd_sc_hd__o21bai_1
X_1784_ _0771_ _0829_ _0832_ _0862_ VGND VGND VPWR VPWR _0865_ sky130_fd_sc_hd__and4_1
XFILLER_37_162 VGND VGND VPWR VPWR sky130_fd_sc_hd__decap_6
X_1149_ net78 _0246_ _0247_ net86 VGND VGND VPWR VPWR _0008_ sky130_fd_sc_hd__o211a_1
X_1218_ _0305_ _0313_ _0314_ VGND VGND VPWR VPWR _0315_ sky130_fd_sc_hd__nand3_1
XTAP_TAPCELL_ROW_50_388 VGND VPWR sky130_fd_sc_hd__tapvpwrvgnd_1
XFILLER_20_44 VGND VGND VPWR VPWR sky130_fd_sc_hd__fill_2
Xhold75 net34 VGND VGND VPWR VPWR net200 sky130_fd_sc_hd__dlygate4sd3_1
XFILLER_28_195 VGND VGND VPWR VPWR sky130_fd_sc_hd__fill_1
XFILLER_28_184 VGND VGND VPWR VPWR sky130_fd_sc_hd__decap_4
XFILLER_6_24 VGND VGND VPWR VPWR sky130_fd_sc_hd__decap_4
XFILLER_3_261 VPWR VGND VPWR VGND sky130_ef_sc_hd__decap_12
Xrebuffer18 _0434_ VGND VGND VPWR VPWR net143 sky130_fd_sc_hd__buf_4
XFILLER_19_140 VGND VGND VPWR VPWR sky130_fd_sc_hd__decap_3
XFILLER_19_173 VGND VGND VPWR VPWR sky130_fd_sc_hd__fill_1
X_1905_ _0988_ _0989_ net178 VGND VGND VPWR VPWR _0991_ sky130_fd_sc_hd__o21a_1
X_1698_ _0743_ _0745_ _0779_ _0780_ VGND VGND VPWR VPWR _0782_ sky130_fd_sc_hd__o211a_1
X_1767_ _0845_ _0846_ _0847_ VGND VGND VPWR VPWR _0849_ sky130_fd_sc_hd__nand3_1
X_1836_ net56 _0918_ VGND VGND VPWR VPWR _0920_ sky130_fd_sc_hd__xnor2_1
XPHY_EDGE_ROW_6_Right_6 VGND VGND VPWR VPWR sky130_fd_sc_hd__decap_3
XFILLER_13_305 VGND VGND VPWR VPWR sky130_fd_sc_hd__decap_4
XFILLER_15_55 VGND VGND VPWR VPWR sky130_fd_sc_hd__fill_1
XFILLER_15_77 VGND VGND VPWR VPWR sky130_fd_sc_hd__decap_8
Xoutput32 net32 VGND VGND VPWR VPWR acc_out[20] sky130_fd_sc_hd__buf_2
XFILLER_31_98 VGND VGND VPWR VPWR sky130_fd_sc_hd__fill_1
XFILLER_0_253 VPWR VGND VPWR VGND sky130_ef_sc_hd__decap_12
Xoutput21 net21 VGND VGND VPWR VPWR acc_out[10] sky130_fd_sc_hd__buf_2
Xoutput43 net43 VGND VGND VPWR VPWR acc_out[30] sky130_fd_sc_hd__buf_2
XFILLER_31_113 VGND VGND VPWR VPWR sky130_fd_sc_hd__decap_3
XFILLER_16_176 VGND VGND VPWR VPWR sky130_fd_sc_hd__fill_2
X_1621_ _0676_ _0647_ _0675_ VGND VGND VPWR VPWR _0708_ sky130_fd_sc_hd__a21o_1
X_1552_ _0637_ _0638_ _0639_ VGND VGND VPWR VPWR _0641_ sky130_fd_sc_hd__a21oi_1
XFILLER_39_268 VPWR VGND VPWR VGND sky130_ef_sc_hd__decap_12
X_1483_ _0549_ _0572_ _0573_ VGND VGND VPWR VPWR _0574_ sky130_fd_sc_hd__nand3_1
X_2035_ clknet_2_3__leaf_clk _0026_ VGND VGND VPWR VPWR net36 sky130_fd_sc_hd__dfxtp_1
X_1819_ net37 net121 net94 VGND VGND VPWR VPWR _0903_ sky130_fd_sc_hd__and3_1
XFILLER_45_205 VGND VGND VPWR VPWR sky130_fd_sc_hd__fill_2
XFILLER_13_113 VGND VGND VPWR VPWR sky130_fd_sc_hd__decap_8
XFILLER_13_146 VGND VGND VPWR VPWR sky130_fd_sc_hd__decap_8
XFILLER_26_98 VPWR VGND VPWR VGND sky130_ef_sc_hd__decap_12
XFILLER_42_64 VGND VGND VPWR VPWR sky130_fd_sc_hd__decap_8
Xrebuffer9 net92 VGND VGND VPWR VPWR net134 sky130_fd_sc_hd__dlygate4sd1_1
XFILLER_44_271 VGND VGND VPWR VPWR sky130_fd_sc_hd__decap_4
X_1604_ net66 _0657_ _0658_ VGND VGND VPWR VPWR _0691_ sky130_fd_sc_hd__a21o_1
X_1535_ net27 net120 net93 VGND VGND VPWR VPWR _0624_ sky130_fd_sc_hd__and3_4
Xfanout118 net123 VGND VGND VPWR VPWR net118 sky130_fd_sc_hd__clkbuf_2
Xfanout107 net18 VGND VGND VPWR VPWR net107 sky130_fd_sc_hd__buf_1
X_1466_ net121 net93 net25 VGND VGND VPWR VPWR _0557_ sky130_fd_sc_hd__a21oi_1
X_1397_ net68 _0444_ _0442_ VGND VGND VPWR VPWR _0490_ sky130_fd_sc_hd__a21o_1
XFILLER_35_260 VGND VGND VPWR VPWR sky130_fd_sc_hd__decap_8
X_2018_ clknet_2_2__leaf_clk _0009_ VGND VGND VPWR VPWR net49 sky130_fd_sc_hd__dfxtp_1
XFILLER_10_105 VGND VGND VPWR VPWR sky130_fd_sc_hd__fill_1
XFILLER_10_138 VGND VGND VPWR VPWR sky130_fd_sc_hd__fill_2
XTAP_TAPCELL_ROW_28_266 VGND VPWR sky130_fd_sc_hd__tapvpwrvgnd_1
XFILLER_41_296 VPWR VGND VPWR VGND sky130_ef_sc_hd__decap_12
X_1320_ _0370_ _0414_ VGND VGND VPWR VPWR _0415_ sky130_fd_sc_hd__nor2_1
X_1182_ _0202_ _0241_ _0240_ VGND VGND VPWR VPWR _0280_ sky130_fd_sc_hd__a21oi_2
X_1251_ net15 net96 net134 net112 VGND VGND VPWR VPWR _0347_ sky130_fd_sc_hd__a22o_1
XFILLER_32_230 VGND VGND VPWR VPWR sky130_fd_sc_hd__fill_1
XFILLER_17_271 VGND VGND VPWR VPWR sky130_fd_sc_hd__decap_8
XFILLER_24_208 VGND VGND VPWR VPWR sky130_fd_sc_hd__decap_6
X_1518_ _0607_ _0606_ _0587_ VGND VGND VPWR VPWR _0608_ sky130_fd_sc_hd__and3_1
X_1449_ _0538_ _0539_ _0476_ _0478_ VGND VGND VPWR VPWR _0541_ sky130_fd_sc_hd__o211a_1
XTAP_TAPCELL_ROW_2_123 VGND VPWR sky130_fd_sc_hd__tapvpwrvgnd_1
XTAP_TAPCELL_ROW_33_291 VGND VPWR sky130_fd_sc_hd__tapvpwrvgnd_1
XFILLER_23_55 VGND VGND VPWR VPWR sky130_fd_sc_hd__fill_1
XTAP_TAPCELL_ROW_25_247 VGND VPWR sky130_fd_sc_hd__tapvpwrvgnd_1
XFILLER_3_3 VPWR VGND VPWR VGND sky130_ef_sc_hd__decap_12
XFILLER_48_85 VPWR VGND VPWR VGND sky130_ef_sc_hd__decap_12
XFILLER_48_41 VPWR VGND VPWR VGND sky130_ef_sc_hd__decap_12
XFILLER_0_15 VPWR VGND VPWR VGND sky130_ef_sc_hd__decap_12
XFILLER_9_57 VGND VGND VPWR VPWR sky130_fd_sc_hd__fill_2
X_1303_ _0395_ _0396_ net162 _0353_ VGND VGND VPWR VPWR _0398_ sky130_fd_sc_hd__a211o_1
XTAP_TAPCELL_ROW_47_372 VGND VPWR sky130_fd_sc_hd__tapvpwrvgnd_1
XTAP_TAPCELL_ROW_39_328 VGND VPWR sky130_fd_sc_hd__tapvpwrvgnd_1
X_1234_ _0328_ _0329_ VGND VGND VPWR VPWR _0331_ sky130_fd_sc_hd__xnor2_2
X_1096_ _0194_ _0195_ VGND VGND VPWR VPWR _0196_ sky130_fd_sc_hd__nor2_1
X_1165_ net118 net169 VGND VGND VPWR VPWR _0263_ sky130_fd_sc_hd__nand2_1
X_1998_ _0090_ _0091_ net140 VGND VGND VPWR VPWR _0120_ sky130_fd_sc_hd__mux2_1
XFILLER_18_33 VGND VGND VPWR VPWR sky130_fd_sc_hd__decap_6
XFILLER_50_53 VPWR VGND VPWR VGND sky130_ef_sc_hd__decap_12
XFILLER_7_237 VPWR VGND VPWR VGND sky130_ef_sc_hd__decap_12
XFILLER_46_141 VGND VGND VPWR VPWR sky130_fd_sc_hd__decap_8
XTAP_TAPCELL_ROW_36_309 VGND VPWR sky130_fd_sc_hd__tapvpwrvgnd_1
XTAP_TAPCELL_ROW_44_353 VGND VPWR sky130_fd_sc_hd__tapvpwrvgnd_1
X_1852_ net69 _0935_ VGND VGND VPWR VPWR _0936_ sky130_fd_sc_hd__xnor2_1
X_1921_ net56 _0038_ VGND VGND VPWR VPWR _0039_ sky130_fd_sc_hd__xnor2_1
X_1783_ net203 net85 _0864_ _0863_ net89 VGND VGND VPWR VPWR _0025_ sky130_fd_sc_hd__o221a_1
X_1148_ net48 net82 VGND VGND VPWR VPWR _0247_ sky130_fd_sc_hd__or2_1
X_1217_ _0310_ _0311_ _0312_ VGND VGND VPWR VPWR _0314_ sky130_fd_sc_hd__a21o_1
X_1079_ _0135_ _0155_ _0154_ VGND VGND VPWR VPWR _0180_ sky130_fd_sc_hd__a21bo_1
XTAP_TAPCELL_ROW_50_389 VGND VPWR sky130_fd_sc_hd__tapvpwrvgnd_1
Xhold76 net30 VGND VGND VPWR VPWR net201 sky130_fd_sc_hd__dlygate4sd3_1
XFILLER_29_65 VGND VGND VPWR VPWR sky130_fd_sc_hd__decap_3
XFILLER_29_54 VGND VGND VPWR VPWR sky130_fd_sc_hd__fill_2
XFILLER_29_21 VGND VGND VPWR VPWR sky130_fd_sc_hd__decap_8
XFILLER_16_303 VGND VGND VPWR VPWR sky130_fd_sc_hd__fill_1
XFILLER_45_97 VGND VGND VPWR VPWR sky130_fd_sc_hd__decap_3
XFILLER_43_166 VGND VGND VPWR VPWR sky130_fd_sc_hd__fill_2
XFILLER_43_111 VGND VGND VPWR VPWR sky130_fd_sc_hd__fill_1
XFILLER_3_273 VGND VGND VPWR VPWR sky130_fd_sc_hd__decap_6
XFILLER_34_166 VGND VGND VPWR VPWR sky130_fd_sc_hd__decap_8
Xrebuffer19 net92 VGND VGND VPWR VPWR net144 sky130_fd_sc_hd__dlygate4sd1_1
X_1835_ net63 _0918_ VGND VGND VPWR VPWR _0919_ sky130_fd_sc_hd__and2_1
X_1904_ net72 _0988_ _0989_ VGND VGND VPWR VPWR _0990_ sky130_fd_sc_hd__nor3_1
X_1697_ _0779_ _0780_ _0743_ _0745_ VGND VGND VPWR VPWR _0781_ sky130_fd_sc_hd__a211o_1
X_1766_ _0845_ _0846_ _0847_ VGND VGND VPWR VPWR _0848_ sky130_fd_sc_hd__a21o_1
XFILLER_25_144 VGND VGND VPWR VPWR sky130_fd_sc_hd__decap_4
Xoutput33 net33 VGND VGND VPWR VPWR acc_out[21] sky130_fd_sc_hd__buf_2
XFILLER_48_225 VPWR VGND VPWR VGND sky130_ef_sc_hd__decap_12
XFILLER_0_265 VPWR VGND VPWR VGND sky130_ef_sc_hd__decap_12
Xoutput22 net22 VGND VGND VPWR VPWR acc_out[11] sky130_fd_sc_hd__buf_2
Xoutput44 net44 VGND VGND VPWR VPWR acc_out[31] sky130_fd_sc_hd__buf_2
X_1620_ _0705_ _0706_ VGND VGND VPWR VPWR _0707_ sky130_fd_sc_hd__and2_4
X_1551_ _0637_ _0638_ _0639_ VGND VGND VPWR VPWR _0640_ sky130_fd_sc_hd__and3_1
X_1482_ _0569_ _0570_ _0571_ VGND VGND VPWR VPWR _0573_ sky130_fd_sc_hd__a21o_1
X_2034_ clknet_2_3__leaf_clk _0025_ VGND VGND VPWR VPWR net35 sky130_fd_sc_hd__dfxtp_1
X_1818_ net80 _0900_ _0902_ net89 VGND VGND VPWR VPWR _0026_ sky130_fd_sc_hd__o211a_1
X_1749_ _0831_ VGND VGND VPWR VPWR _0832_ sky130_fd_sc_hd__inv_2
XPHY_EDGE_ROW_37_Left_89 VGND VGND VPWR VPWR sky130_fd_sc_hd__decap_3
XFILLER_26_44 VPWR VGND VPWR VGND sky130_ef_sc_hd__decap_12
XFILLER_13_169 VGND VGND VPWR VPWR sky130_fd_sc_hd__fill_2
XPHY_EDGE_ROW_48_Left_100 VGND VGND VPWR VPWR sky130_fd_sc_hd__decap_3
XFILLER_3_15 VGND VGND VPWR VPWR sky130_fd_sc_hd__decap_8
XFILLER_29_291 VGND VGND VPWR VPWR sky130_fd_sc_hd__fill_2
XFILLER_8_195 VGND VGND VPWR VPWR sky130_fd_sc_hd__fill_1
XTAP_TAPCELL_ROW_14_186 VGND VPWR sky130_fd_sc_hd__tapvpwrvgnd_1
X_1603_ _0686_ _0688_ net66 VGND VGND VPWR VPWR _0690_ sky130_fd_sc_hd__a21o_1
X_1465_ net25 net121 net93 VGND VGND VPWR VPWR _0556_ sky130_fd_sc_hd__and3_4
Xfanout119 net123 VGND VGND VPWR VPWR net119 sky130_fd_sc_hd__dlymetal6s2s_1
X_1534_ _0619_ _0546_ _0510_ _0621_ _0622_ VGND VGND VPWR VPWR _0623_ sky130_fd_sc_hd__o311ai_4
Xfanout108 net17 VGND VGND VPWR VPWR net108 sky130_fd_sc_hd__buf_2
X_2017_ clknet_2_0__leaf_clk _0008_ VGND VGND VPWR VPWR net48 sky130_fd_sc_hd__dfxtp_1
X_1396_ _0486_ _0487_ net68 VGND VGND VPWR VPWR _0489_ sky130_fd_sc_hd__a21o_1
XFILLER_50_253 VPWR VGND VPWR VGND sky130_ef_sc_hd__decap_12
XFILLER_37_98 VGND VGND VPWR VPWR sky130_fd_sc_hd__fill_1
XTAP_TAPCELL_ROW_28_267 VGND VPWR sky130_fd_sc_hd__tapvpwrvgnd_1
XFILLER_18_217 VGND VGND VPWR VPWR sky130_fd_sc_hd__fill_1
XFILLER_38_7 VGND VGND VPWR VPWR sky130_fd_sc_hd__fill_2
X_1181_ _0218_ _0278_ VGND VGND VPWR VPWR _0279_ sky130_fd_sc_hd__xnor2_1
X_1250_ net112 net15 net92 VGND VGND VPWR VPWR _0346_ sky130_fd_sc_hd__and3_1
XFILLER_32_253 VPWR VGND VPWR VGND sky130_ef_sc_hd__decap_12
X_1517_ _0604_ _0603_ _0605_ VGND VGND VPWR VPWR _0607_ sky130_fd_sc_hd__a21o_1
X_1448_ _0476_ _0478_ _0538_ _0539_ VGND VGND VPWR VPWR _0540_ sky130_fd_sc_hd__a211oi_2
XTAP_TAPCELL_ROW_2_124 VGND VPWR sky130_fd_sc_hd__tapvpwrvgnd_1
X_1379_ net96 net107 net144 net109 VGND VGND VPWR VPWR _0472_ sky130_fd_sc_hd__a22o_1
XTAP_TAPCELL_ROW_25_248 VGND VPWR sky130_fd_sc_hd__tapvpwrvgnd_1
XTAP_TAPCELL_ROW_33_292 VGND VPWR sky130_fd_sc_hd__tapvpwrvgnd_1
XFILLER_48_97 VGND VGND VPWR VPWR sky130_fd_sc_hd__decap_8
XFILLER_48_53 VGND VGND VPWR VPWR sky130_fd_sc_hd__decap_8
XFILLER_46_301 VGND VGND VPWR VPWR sky130_fd_sc_hd__decap_6
XFILLER_0_27 VGND VGND VPWR VPWR sky130_fd_sc_hd__fill_1
XFILLER_9_25 VGND VGND VPWR VPWR sky130_fd_sc_hd__decap_4
XFILLER_14_253 VPWR VGND VPWR VGND sky130_ef_sc_hd__decap_12
Xfanout90 net91 VGND VGND VPWR VPWR net90 sky130_fd_sc_hd__buf_8
XPHY_EDGE_ROW_24_Left_76 VGND VGND VPWR VPWR sky130_fd_sc_hd__decap_3
X_1233_ _0328_ _0329_ VGND VGND VPWR VPWR _0330_ sky130_fd_sc_hd__and2b_1
X_1302_ net163 _0353_ _0395_ _0396_ VGND VGND VPWR VPWR _0397_ sky130_fd_sc_hd__o211ai_2
X_1095_ net166 net100 net111 net102 VGND VGND VPWR VPWR _0195_ sky130_fd_sc_hd__a22oi_1
X_1164_ net118 net169 VGND VGND VPWR VPWR _0262_ sky130_fd_sc_hd__and2_2
X_1997_ net44 _0117_ VGND VGND VPWR VPWR _0119_ sky130_fd_sc_hd__xnor2_1
XFILLER_43_304 VGND VGND VPWR VPWR sky130_fd_sc_hd__decap_4
XFILLER_34_22 VGND VGND VPWR VPWR sky130_fd_sc_hd__decap_6
XFILLER_50_65 VGND VGND VPWR VPWR sky130_fd_sc_hd__decap_4
XFILLER_7_249 VPWR VGND VPWR VGND sky130_ef_sc_hd__decap_12
XFILLER_11_256 VPWR VGND VPWR VGND sky130_ef_sc_hd__decap_12
XFILLER_46_186 VGND VGND VPWR VPWR sky130_fd_sc_hd__decap_6
XFILLER_19_301 VGND VGND VPWR VPWR sky130_fd_sc_hd__decap_4
XTAP_TAPCELL_ROW_44_354 VGND VPWR sky130_fd_sc_hd__tapvpwrvgnd_1
X_1851_ _0932_ _0933_ VGND VGND VPWR VPWR _0935_ sky130_fd_sc_hd__xnor2_1
X_1920_ _0035_ _0036_ VGND VGND VPWR VPWR _0038_ sky130_fd_sc_hd__xnor2_1
X_1782_ _0835_ _0828_ _0862_ net80 VGND VGND VPWR VPWR _0864_ sky130_fd_sc_hd__a31o_1
XFILLER_37_142 VGND VGND VPWR VPWR sky130_fd_sc_hd__decap_8
X_1216_ _0310_ _0311_ _0312_ VGND VGND VPWR VPWR _0313_ sky130_fd_sc_hd__nand3_1
XFILLER_37_186 VGND VGND VPWR VPWR sky130_fd_sc_hd__fill_1
X_1147_ _0244_ _0245_ VGND VGND VPWR VPWR _0246_ sky130_fd_sc_hd__and2_1
X_1078_ _0177_ _0178_ VGND VGND VPWR VPWR _0179_ sky130_fd_sc_hd__or2_1
XFILLER_25_304 VGND VGND VPWR VPWR sky130_fd_sc_hd__fill_1
XFILLER_20_13 VPWR VGND VPWR VGND sky130_ef_sc_hd__decap_12
XFILLER_29_77 VGND VGND VPWR VPWR sky130_fd_sc_hd__decap_3
Xhold77 net50 VGND VGND VPWR VPWR net202 sky130_fd_sc_hd__dlygate4sd3_1
XTAP_TAPCELL_ROW_41_335 VGND VPWR sky130_fd_sc_hd__tapvpwrvgnd_1
XFILLER_19_120 VPWR VGND VPWR VGND sky130_ef_sc_hd__decap_12
XFILLER_22_307 VGND VGND VPWR VPWR sky130_fd_sc_hd__fill_1
X_1765_ net69 _0809_ _0810_ VGND VGND VPWR VPWR _0847_ sky130_fd_sc_hd__a21o_1
X_1834_ _0915_ _0916_ VGND VGND VPWR VPWR _0918_ sky130_fd_sc_hd__xnor2_1
X_1903_ net40 _0262_ VGND VGND VPWR VPWR _0989_ sky130_fd_sc_hd__nor2_1
X_1696_ _0776_ _0777_ net75 VGND VGND VPWR VPWR _0780_ sky130_fd_sc_hd__o21ai_1
XPHY_EDGE_ROW_11_Left_63 VGND VGND VPWR VPWR sky130_fd_sc_hd__decap_3
XFILLER_40_159 VGND VGND VPWR VPWR sky130_fd_sc_hd__decap_8
Xoutput34 net34 VGND VGND VPWR VPWR acc_out[22] sky130_fd_sc_hd__buf_2
Xoutput23 net23 VGND VGND VPWR VPWR acc_out[12] sky130_fd_sc_hd__buf_2
XFILLER_48_237 VPWR VGND VPWR VGND sky130_ef_sc_hd__decap_12
XFILLER_0_277 VGND VGND VPWR VPWR sky130_fd_sc_hd__decap_3
XFILLER_0_233 VGND VGND VPWR VPWR sky130_fd_sc_hd__fill_1
Xoutput45 net45 VGND VGND VPWR VPWR acc_out[3] sky130_fd_sc_hd__buf_2
XFILLER_31_104 VGND VGND VPWR VPWR sky130_fd_sc_hd__decap_8
X_1550_ net58 _0602_ _0601_ VGND VGND VPWR VPWR _0639_ sky130_fd_sc_hd__o21bai_1
X_1481_ _0569_ _0570_ _0571_ VGND VGND VPWR VPWR _0572_ sky130_fd_sc_hd__nand3_1
XFILLER_47_281 VPWR VGND VPWR VGND sky130_ef_sc_hd__decap_12
X_2033_ clknet_2_3__leaf_clk _0024_ VGND VGND VPWR VPWR net34 sky130_fd_sc_hd__dfxtp_1
XFILLER_11_3 VGND VGND VPWR VPWR sky130_fd_sc_hd__decap_3
XFILLER_22_126 VGND VGND VPWR VPWR sky130_fd_sc_hd__decap_8
X_1817_ net36 net85 VGND VGND VPWR VPWR _0902_ sky130_fd_sc_hd__or2_1
X_1748_ _0768_ _0801_ VGND VGND VPWR VPWR _0831_ sky130_fd_sc_hd__nand2_2
X_1679_ _0761_ _0762_ _0763_ VGND VGND VPWR VPWR _0764_ sky130_fd_sc_hd__and3_1
XFILLER_26_56 VGND VGND VPWR VPWR sky130_fd_sc_hd__fill_1
XFILLER_13_126 VGND VGND VPWR VPWR sky130_fd_sc_hd__fill_1
XFILLER_13_159 VGND VGND VPWR VPWR sky130_fd_sc_hd__decap_8
XFILLER_36_229 VGND VGND VPWR VPWR sky130_fd_sc_hd__fill_1
XFILLER_36_207 VGND VGND VPWR VPWR sky130_fd_sc_hd__decap_6
X_1602_ net64 _0687_ _0686_ VGND VGND VPWR VPWR _0689_ sky130_fd_sc_hd__or3b_4
XFILLER_8_141 VGND VGND VPWR VPWR sky130_fd_sc_hd__decap_3
XTAP_TAPCELL_ROW_14_187 VGND VPWR sky130_fd_sc_hd__tapvpwrvgnd_1
X_1533_ _0579_ _0614_ _0613_ VGND VGND VPWR VPWR _0622_ sky130_fd_sc_hd__a21oi_1
X_1464_ _0518_ _0552_ _0553_ _0554_ VGND VGND VPWR VPWR _0555_ sky130_fd_sc_hd__a211oi_2
Xfanout109 net17 VGND VGND VPWR VPWR net109 sky130_fd_sc_hd__dlymetal6s2s_1
X_1395_ net65 _0485_ _0487_ VGND VGND VPWR VPWR _0488_ sky130_fd_sc_hd__or3b_1
X_2016_ clknet_2_0__leaf_clk _0007_ VGND VGND VPWR VPWR net47 sky130_fd_sc_hd__dfxtp_1
XFILLER_50_265 VPWR VGND VPWR VGND sky130_ef_sc_hd__decap_12
XFILLER_37_55 VGND VGND VPWR VPWR sky130_fd_sc_hd__fill_1
XTAP_TAPCELL_ROW_28_268 VGND VPWR sky130_fd_sc_hd__tapvpwrvgnd_1
XFILLER_26_251 VGND VGND VPWR VPWR sky130_fd_sc_hd__fill_1
X_1180_ _0275_ _0276_ VGND VGND VPWR VPWR _0278_ sky130_fd_sc_hd__xnor2_1
XFILLER_32_287 VGND VGND VPWR VPWR sky130_fd_sc_hd__decap_4
XFILLER_32_265 VPWR VGND VPWR VGND sky130_ef_sc_hd__decap_12
XFILLER_32_243 VGND VGND VPWR VPWR sky130_fd_sc_hd__decap_8
XFILLER_32_210 VGND VGND VPWR VPWR sky130_fd_sc_hd__fill_1
X_1516_ net180 _0604_ _0605_ VGND VGND VPWR VPWR _0606_ sky130_fd_sc_hd__nand3_1
XTAP_TAPCELL_ROW_2_125 VGND VPWR sky130_fd_sc_hd__tapvpwrvgnd_1
X_1378_ net109 net107 net131 VGND VGND VPWR VPWR _0471_ sky130_fd_sc_hd__and3_4
X_1447_ _0536_ _0537_ _0491_ _0494_ VGND VGND VPWR VPWR _0539_ sky130_fd_sc_hd__a211oi_1
XFILLER_23_210 VPWR VGND VPWR VGND sky130_ef_sc_hd__decap_12
XTAP_TAPCELL_ROW_25_249 VGND VPWR sky130_fd_sc_hd__tapvpwrvgnd_1
XTAP_TAPCELL_ROW_33_293 VGND VPWR sky130_fd_sc_hd__tapvpwrvgnd_1
XFILLER_23_57 VGND VGND VPWR VPWR sky130_fd_sc_hd__fill_1
XFILLER_2_169 VGND VGND VPWR VPWR sky130_fd_sc_hd__fill_1
Xfanout80 net81 VGND VGND VPWR VPWR net80 sky130_fd_sc_hd__buf_2
Xfanout91 net92 VGND VGND VPWR VPWR net91 sky130_fd_sc_hd__buf_8
XFILLER_14_265 VPWR VGND VPWR VGND sky130_ef_sc_hd__decap_12
XFILLER_13_90 VGND VGND VPWR VPWR sky130_fd_sc_hd__decap_8
X_1232_ _0249_ _0282_ _0281_ VGND VGND VPWR VPWR _0329_ sky130_fd_sc_hd__o21ai_2
X_1301_ _0392_ _0393_ net71 VGND VGND VPWR VPWR _0396_ sky130_fd_sc_hd__o21ai_1
X_1094_ net102 net165 net100 net111 VGND VGND VPWR VPWR _0194_ sky130_fd_sc_hd__and4_1
X_1163_ _0221_ _0260_ VGND VGND VPWR VPWR _0261_ sky130_fd_sc_hd__xnor2_1
XTAP_TAPCELL_ROW_30_274 VGND VPWR sky130_fd_sc_hd__tapvpwrvgnd_1
X_1996_ net43 net70 _0116_ VGND VGND VPWR VPWR _0117_ sky130_fd_sc_hd__o21ai_1
XFILLER_20_246 VGND VGND VPWR VPWR sky130_fd_sc_hd__decap_6
XFILLER_28_302 VGND VGND VPWR VPWR sky130_fd_sc_hd__decap_6
XPHY_EDGE_ROW_41_Left_93 VGND VGND VPWR VPWR sky130_fd_sc_hd__decap_3
XFILLER_34_67 VGND VGND VPWR VPWR sky130_fd_sc_hd__fill_2
XFILLER_11_268 VPWR VGND VPWR VGND sky130_ef_sc_hd__decap_12
Xclkload0 clknet_2_0__leaf_clk VGND VGND VPWR VPWR clkload0/Y sky130_fd_sc_hd__clkinv_2
XFILLER_46_132 VGND VGND VPWR VPWR sky130_fd_sc_hd__decap_8
XTAP_TAPCELL_ROW_44_355 VGND VPWR sky130_fd_sc_hd__tapvpwrvgnd_1
XFILLER_34_305 VGND VGND VPWR VPWR sky130_fd_sc_hd__decap_3
X_1781_ _0828_ _0835_ _0862_ VGND VGND VPWR VPWR _0863_ sky130_fd_sc_hd__a21oi_2
X_1850_ _0932_ _0933_ VGND VGND VPWR VPWR _0934_ sky130_fd_sc_hd__nand2_1
X_1146_ _0207_ _0210_ _0243_ VGND VGND VPWR VPWR _0245_ sky130_fd_sc_hd__or3_1
X_1215_ _0263_ _0265_ _0264_ VGND VGND VPWR VPWR _0312_ sky130_fd_sc_hd__o21ai_1
X_1077_ _0175_ _0176_ _0148_ VGND VGND VPWR VPWR _0178_ sky130_fd_sc_hd__o21a_1
XFILLER_20_25 VGND VGND VPWR VPWR sky130_fd_sc_hd__decap_3
X_1979_ _0070_ _0072_ _0098_ VGND VGND VPWR VPWR _0100_ sky130_fd_sc_hd__o21a_1
XFILLER_29_34 VPWR VGND VPWR VGND sky130_ef_sc_hd__decap_12
XFILLER_45_77 VPWR VGND VPWR VGND sky130_ef_sc_hd__decap_12
XFILLER_45_55 VGND VGND VPWR VPWR sky130_fd_sc_hd__fill_1
Xhold78 net35 VGND VGND VPWR VPWR net203 sky130_fd_sc_hd__dlygate4sd3_1
XFILLER_28_176 VGND VGND VPWR VPWR sky130_fd_sc_hd__fill_1
XFILLER_28_154 VGND VGND VPWR VPWR sky130_fd_sc_hd__decap_8
XTAP_TAPCELL_ROW_41_336 VGND VPWR sky130_fd_sc_hd__tapvpwrvgnd_1
XFILLER_10_80 VGND VGND VPWR VPWR sky130_fd_sc_hd__decap_4
XFILLER_19_132 VGND VGND VPWR VPWR sky130_fd_sc_hd__decap_8
X_1902_ net40 net119 net92 VGND VGND VPWR VPWR _0988_ sky130_fd_sc_hd__and3_1
X_1764_ _0843_ _0844_ net69 VGND VGND VPWR VPWR _0846_ sky130_fd_sc_hd__a21o_1
X_1833_ _0916_ _0915_ VGND VGND VPWR VPWR _0917_ sky130_fd_sc_hd__and2b_1
X_1695_ net75 _0776_ _0777_ VGND VGND VPWR VPWR _0779_ sky130_fd_sc_hd__or3_1
X_1129_ net48 net116 net97 VGND VGND VPWR VPWR _0228_ sky130_fd_sc_hd__and3_1
XFILLER_25_113 VPWR VGND VPWR VGND sky130_ef_sc_hd__decap_12
XFILLER_15_47 VGND VGND VPWR VPWR sky130_fd_sc_hd__fill_1
Xoutput35 net35 VGND VGND VPWR VPWR acc_out[23] sky130_fd_sc_hd__buf_2
Xoutput24 net24 VGND VGND VPWR VPWR acc_out[13] sky130_fd_sc_hd__buf_2
Xoutput46 net46 VGND VGND VPWR VPWR acc_out[4] sky130_fd_sc_hd__buf_2
XFILLER_48_249 VGND VGND VPWR VPWR sky130_fd_sc_hd__decap_3
XFILLER_0_223 VGND VGND VPWR VPWR sky130_fd_sc_hd__fill_1
XPHY_EDGE_ROW_19_Right_19 VGND VGND VPWR VPWR sky130_fd_sc_hd__decap_3
XFILLER_8_301 VGND VGND VPWR VPWR sky130_fd_sc_hd__decap_6
XPHY_EDGE_ROW_28_Right_28 VGND VGND VPWR VPWR sky130_fd_sc_hd__decap_3
X_1480_ _0522_ _0535_ _0534_ VGND VGND VPWR VPWR _0571_ sky130_fd_sc_hd__a21bo_1
XFILLER_47_293 VPWR VGND VPWR VGND sky130_ef_sc_hd__decap_12
X_2032_ clknet_2_1__leaf_clk _0023_ VGND VGND VPWR VPWR net33 sky130_fd_sc_hd__dfxtp_1
XPHY_EDGE_ROW_37_Right_37 VGND VGND VPWR VPWR sky130_fd_sc_hd__decap_3
XFILLER_22_116 VGND VGND VPWR VPWR sky130_fd_sc_hd__decap_6
XPHY_EDGE_ROW_46_Right_46 VGND VGND VPWR VPWR sky130_fd_sc_hd__decap_3
X_1678_ net61 _0730_ _0731_ VGND VGND VPWR VPWR _0763_ sky130_fd_sc_hd__a21bo_1
X_1816_ _0871_ _0898_ VGND VGND VPWR VPWR _0900_ sky130_fd_sc_hd__xnor2_1
X_1747_ _0764_ _0799_ _0767_ VGND VGND VPWR VPWR _0830_ sky130_fd_sc_hd__o21ba_1
XFILLER_30_193 VGND VGND VPWR VPWR sky130_fd_sc_hd__decap_3
XFILLER_7_81 VGND VGND VPWR VPWR sky130_fd_sc_hd__decap_8
XFILLER_13_105 VGND VGND VPWR VPWR sky130_fd_sc_hd__decap_6
XFILLER_26_79 VGND VGND VPWR VPWR sky130_fd_sc_hd__fill_2
XFILLER_42_78 VGND VGND VPWR VPWR sky130_fd_sc_hd__decap_6
XFILLER_42_23 VGND VGND VPWR VPWR sky130_fd_sc_hd__decap_4
XFILLER_9_109 VGND VGND VPWR VPWR sky130_fd_sc_hd__decap_3
XTAP_TAPCELL_ROW_8_153 VGND VPWR sky130_fd_sc_hd__tapvpwrvgnd_1
XTAP_TAPCELL_ROW_14_188 VGND VPWR sky130_fd_sc_hd__tapvpwrvgnd_1
X_1601_ _0652_ _0654_ _0684_ _0685_ VGND VGND VPWR VPWR _0688_ sky130_fd_sc_hd__o211ai_1
X_1532_ _0505_ _0545_ _0620_ VGND VGND VPWR VPWR _0621_ sky130_fd_sc_hd__a21bo_1
XFILLER_8_197 VGND VGND VPWR VPWR sky130_fd_sc_hd__fill_1
X_1394_ _0483_ _0484_ _0437_ _0439_ VGND VGND VPWR VPWR _0487_ sky130_fd_sc_hd__a211o_1
X_1463_ _0469_ _0518_ VGND VGND VPWR VPWR _0554_ sky130_fd_sc_hd__nor2_1
XFILLER_35_241 VPWR VGND VPWR VGND sky130_ef_sc_hd__decap_12
X_2015_ clknet_2_0__leaf_clk _0006_ VGND VGND VPWR VPWR net46 sky130_fd_sc_hd__dfxtp_1
XFILLER_50_277 VPWR VGND VPWR VGND sky130_ef_sc_hd__decap_12
XFILLER_5_9 VGND VGND VPWR VPWR sky130_fd_sc_hd__fill_1
XFILLER_2_307 VGND VGND VPWR VPWR sky130_fd_sc_hd__fill_1
XFILLER_37_23 VGND VGND VPWR VPWR sky130_fd_sc_hd__decap_3
XFILLER_18_208 VGND VGND VPWR VPWR sky130_fd_sc_hd__fill_1
XFILLER_41_277 VGND VGND VPWR VPWR sky130_fd_sc_hd__decap_3
XFILLER_41_222 VGND VGND VPWR VPWR sky130_fd_sc_hd__fill_2
XFILLER_26_274 VGND VGND VPWR VPWR sky130_fd_sc_hd__decap_4
XFILLER_5_101 VGND VGND VPWR VPWR sky130_fd_sc_hd__fill_1
XTAP_TAPCELL_ROW_19_214 VGND VPWR sky130_fd_sc_hd__tapvpwrvgnd_1
XFILLER_32_277 VGND VGND VPWR VPWR sky130_fd_sc_hd__decap_6
X_1515_ _0555_ _0568_ _0567_ VGND VGND VPWR VPWR _0605_ sky130_fd_sc_hd__a21bo_1
X_1446_ _0491_ _0494_ _0536_ _0537_ VGND VGND VPWR VPWR _0538_ sky130_fd_sc_hd__o211a_1
XFILLER_4_82 VGND VGND VPWR VPWR sky130_fd_sc_hd__fill_2
XFILLER_4_71 VGND VGND VPWR VPWR sky130_fd_sc_hd__decap_6
X_1377_ _0469_ VGND VGND VPWR VPWR _0470_ sky130_fd_sc_hd__inv_2
XFILLER_23_222 VGND VGND VPWR VPWR sky130_fd_sc_hd__fill_2
XFILLER_23_244 VPWR VGND VPWR VGND sky130_ef_sc_hd__decap_12
XTAP_TAPCELL_ROW_33_294 VGND VPWR sky130_fd_sc_hd__tapvpwrvgnd_1
XFILLER_2_159 VGND VGND VPWR VPWR sky130_fd_sc_hd__fill_1
XFILLER_2_126 VPWR VGND VPWR VGND sky130_ef_sc_hd__decap_12
XFILLER_0_29 VGND VGND VPWR VPWR sky130_fd_sc_hd__fill_2
Xfanout81 _0901_ VGND VGND VPWR VPWR net81 sky130_fd_sc_hd__buf_2
Xfanout92 net8 VGND VGND VPWR VPWR net92 sky130_fd_sc_hd__buf_8
XFILLER_14_277 VPWR VGND VPWR VGND sky130_ef_sc_hd__decap_12
Xfanout70 net77 VGND VGND VPWR VPWR net70 sky130_fd_sc_hd__buf_6
XFILLER_49_196 VGND VGND VPWR VPWR sky130_fd_sc_hd__decap_3
X_1231_ _0288_ _0326_ VGND VGND VPWR VPWR _0328_ sky130_fd_sc_hd__xnor2_1
X_1162_ _0258_ _0259_ VGND VGND VPWR VPWR _0260_ sky130_fd_sc_hd__nor2_1
X_1300_ net71 _0392_ _0393_ VGND VGND VPWR VPWR _0395_ sky130_fd_sc_hd__or3_4
X_1093_ net104 net110 VGND VGND VPWR VPWR _0193_ sky130_fd_sc_hd__nand2_1
XTAP_TAPCELL_ROW_30_275 VGND VPWR sky130_fd_sc_hd__tapvpwrvgnd_1
XFILLER_9_281 VPWR VGND VPWR VGND sky130_ef_sc_hd__decap_12
X_1995_ net43 net70 _0263_ VGND VGND VPWR VPWR _0116_ sky130_fd_sc_hd__a21o_1
X_1429_ _0469_ _0519_ VGND VGND VPWR VPWR _0521_ sky130_fd_sc_hd__xnor2_1
XTAP_TAPCELL_ROW_38_320 VGND VPWR sky130_fd_sc_hd__tapvpwrvgnd_1
XFILLER_11_203 VGND VGND VPWR VPWR sky130_fd_sc_hd__decap_4
XFILLER_11_225 VGND VGND VPWR VPWR sky130_fd_sc_hd__decap_6
Xclkload1 clknet_2_2__leaf_clk VGND VGND VPWR VPWR clkload1/X sky130_fd_sc_hd__clkbuf_4
XFILLER_1_3 VPWR VGND VPWR VGND sky130_ef_sc_hd__decap_12
XFILLER_46_111 VGND VGND VPWR VPWR sky130_fd_sc_hd__decap_6
XTAP_TAPCELL_ROW_44_356 VGND VPWR sky130_fd_sc_hd__tapvpwrvgnd_1
X_1780_ _0860_ _0861_ VGND VGND VPWR VPWR _0862_ sky130_fd_sc_hd__and2_1
XFILLER_34_3 VGND VGND VPWR VPWR sky130_fd_sc_hd__decap_3
X_1145_ _0207_ _0210_ _0243_ VGND VGND VPWR VPWR _0244_ sky130_fd_sc_hd__o21ai_2
X_1214_ _0307_ _0308_ net70 VGND VGND VPWR VPWR _0311_ sky130_fd_sc_hd__o21ai_1
X_1076_ _0148_ _0175_ _0176_ VGND VGND VPWR VPWR _0177_ sky130_fd_sc_hd__nor3_1
X_1978_ _0070_ _0072_ _0098_ VGND VGND VPWR VPWR _0099_ sky130_fd_sc_hd__nor3_1
XFILLER_29_57 VGND VGND VPWR VPWR sky130_fd_sc_hd__decap_8
XFILLER_29_46 VGND VGND VPWR VPWR sky130_fd_sc_hd__decap_8
Xhold79 net20 VGND VGND VPWR VPWR net204 sky130_fd_sc_hd__dlygate4sd3_1
XFILLER_45_89 VGND VGND VPWR VPWR sky130_fd_sc_hd__decap_8
XFILLER_45_67 VGND VGND VPWR VPWR sky130_fd_sc_hd__decap_4
XFILLER_43_125 VGND VGND VPWR VPWR sky130_fd_sc_hd__decap_8
XFILLER_28_133 VGND VGND VPWR VPWR sky130_fd_sc_hd__decap_6
XFILLER_51_191 VGND VGND VPWR VPWR sky130_fd_sc_hd__fill_1
XTAP_TAPCELL_ROW_41_337 VGND VPWR sky130_fd_sc_hd__tapvpwrvgnd_1
X_1832_ net59 _0884_ _0883_ VGND VGND VPWR VPWR _0916_ sky130_fd_sc_hd__o21a_1
X_1901_ net39 net85 _0986_ _0987_ net89 VGND VGND VPWR VPWR _0029_ sky130_fd_sc_hd__o221a_1
X_1694_ net75 _0776_ _0777_ VGND VGND VPWR VPWR _0778_ sky130_fd_sc_hd__nor3_1
X_1763_ net69 _0843_ _0844_ VGND VGND VPWR VPWR _0845_ sky130_fd_sc_hd__nand3_1
X_1059_ net104 net102 net165 net111 VGND VGND VPWR VPWR _0160_ sky130_fd_sc_hd__and4_1
X_1128_ net116 net97 net48 VGND VGND VPWR VPWR _0227_ sky130_fd_sc_hd__a21oi_1
XFILLER_25_125 VGND VGND VPWR VPWR sky130_fd_sc_hd__fill_1
Xoutput36 net36 VGND VGND VPWR VPWR acc_out[24] sky130_fd_sc_hd__buf_2
Xoutput25 net25 VGND VGND VPWR VPWR acc_out[14] sky130_fd_sc_hd__buf_2
XFILLER_0_246 VGND VGND VPWR VPWR sky130_fd_sc_hd__fill_2
Xoutput47 net47 VGND VGND VPWR VPWR acc_out[5] sky130_fd_sc_hd__buf_2
XFILLER_16_114 VPWR VGND VPWR VGND sky130_ef_sc_hd__decap_12
X_2031_ clknet_2_1__leaf_clk _0022_ VGND VGND VPWR VPWR net32 sky130_fd_sc_hd__dfxtp_1
XFILLER_22_106 VGND VGND VPWR VPWR sky130_fd_sc_hd__decap_3
X_1815_ _0871_ _0898_ VGND VGND VPWR VPWR _0899_ sky130_fd_sc_hd__nand2b_4
XFILLER_15_191 VGND VGND VPWR VPWR sky130_fd_sc_hd__fill_1
X_1677_ _0759_ _0760_ net62 VGND VGND VPWR VPWR _0762_ sky130_fd_sc_hd__a21o_1
X_1746_ _0797_ _0827_ VGND VGND VPWR VPWR _0829_ sky130_fd_sc_hd__xnor2_2
XFILLER_5_305 VGND VGND VPWR VPWR sky130_fd_sc_hd__decap_4
XTAP_TAPCELL_ROW_8_154 VGND VPWR sky130_fd_sc_hd__tapvpwrvgnd_1
XFILLER_44_253 VGND VGND VPWR VPWR sky130_fd_sc_hd__decap_6
XTAP_TAPCELL_ROW_14_189 VGND VPWR sky130_fd_sc_hd__tapvpwrvgnd_1
X_1600_ _0652_ _0654_ _0684_ _0685_ VGND VGND VPWR VPWR _0687_ sky130_fd_sc_hd__o211a_1
X_1531_ _0615_ _0580_ _0544_ VGND VGND VPWR VPWR _0620_ sky130_fd_sc_hd__and3_1
X_1462_ _0551_ _0471_ VGND VGND VPWR VPWR _0553_ sky130_fd_sc_hd__and2_4
X_1393_ _0437_ _0439_ _0483_ _0484_ VGND VGND VPWR VPWR _0486_ sky130_fd_sc_hd__o211ai_1
XFILLER_50_234 VPWR VGND VPWR VGND sky130_ef_sc_hd__decap_12
XFILLER_35_253 VGND VGND VPWR VPWR sky130_fd_sc_hd__fill_1
XFILLER_35_220 VGND VGND VPWR VPWR sky130_fd_sc_hd__decap_4
X_2014_ clknet_2_0__leaf_clk _0005_ VGND VGND VPWR VPWR net45 sky130_fd_sc_hd__dfxtp_1
XFILLER_50_289 VPWR VGND VPWR VGND sky130_ef_sc_hd__decap_12
XFILLER_12_49 VPWR VGND VPWR VGND sky130_ef_sc_hd__decap_12
X_1729_ _0810_ net140 _0809_ VGND VGND VPWR VPWR _0812_ sky130_fd_sc_hd__or3b_1
XFILLER_37_57 VPWR VGND VPWR VGND sky130_ef_sc_hd__decap_12
XFILLER_26_253 VPWR VGND VPWR VGND sky130_ef_sc_hd__decap_12
XFILLER_26_231 VPWR VGND VPWR VGND sky130_ef_sc_hd__decap_12
XFILLER_5_113 VGND VGND VPWR VPWR sky130_fd_sc_hd__decap_4
XFILLER_17_231 VGND VGND VPWR VPWR sky130_fd_sc_hd__fill_2
XTAP_TAPCELL_ROW_19_215 VGND VPWR sky130_fd_sc_hd__tapvpwrvgnd_1
X_1514_ _0601_ _0602_ net58 VGND VGND VPWR VPWR _0604_ sky130_fd_sc_hd__o21ai_1
X_1445_ _0534_ _0535_ _0522_ VGND VGND VPWR VPWR _0537_ sky130_fd_sc_hd__a21o_1
X_1376_ net16 net171 net130 VGND VGND VPWR VPWR _0469_ sky130_fd_sc_hd__a21o_4
XTAP_TAPCELL_ROW_33_295 VGND VPWR sky130_fd_sc_hd__tapvpwrvgnd_1
XFILLER_23_256 VGND VGND VPWR VPWR sky130_fd_sc_hd__decap_4
XFILLER_23_267 VPWR VGND VPWR VGND sky130_ef_sc_hd__decap_12
XFILLER_2_138 VGND VGND VPWR VPWR sky130_fd_sc_hd__fill_2
XFILLER_14_201 VGND VGND VPWR VPWR sky130_fd_sc_hd__decap_6
Xfanout93 net95 VGND VGND VPWR VPWR net93 sky130_fd_sc_hd__buf_6
Xfanout60 _0589_ VGND VGND VPWR VPWR net60 sky130_fd_sc_hd__buf_6
XFILLER_14_289 VPWR VGND VPWR VGND sky130_ef_sc_hd__decap_12
Xfanout71 net77 VGND VGND VPWR VPWR net71 sky130_fd_sc_hd__clkbuf_2
Xfanout82 _0890_ VGND VGND VPWR VPWR net82 sky130_fd_sc_hd__buf_2
XFILLER_36_7 VGND VGND VPWR VPWR sky130_fd_sc_hd__fill_2
XFILLER_49_164 VGND VGND VPWR VPWR sky130_fd_sc_hd__decap_4
X_1230_ _0288_ _0326_ VGND VGND VPWR VPWR _0327_ sky130_fd_sc_hd__and2_1
X_1092_ _0189_ _0190_ _0166_ _0168_ VGND VGND VPWR VPWR _0192_ sky130_fd_sc_hd__a211o_1
X_1161_ net114 net97 net98 net172 VGND VGND VPWR VPWR _0259_ sky130_fd_sc_hd__a22oi_1
X_1994_ net63 _0101_ _0100_ VGND VGND VPWR VPWR _0115_ sky130_fd_sc_hd__a21o_1
XTAP_TAPCELL_ROW_30_276 VGND VPWR sky130_fd_sc_hd__tapvpwrvgnd_1
XFILLER_9_293 VPWR VGND VPWR VGND sky130_ef_sc_hd__decap_12
XFILLER_18_15 VPWR VGND VPWR VGND sky130_ef_sc_hd__decap_12
X_1428_ _0470_ _0519_ VGND VGND VPWR VPWR _0520_ sky130_fd_sc_hd__nor2_1
XTAP_TAPCELL_ROW_38_321 VGND VPWR sky130_fd_sc_hd__tapvpwrvgnd_1
X_1359_ _0405_ _0402_ _0451_ _0452_ VGND VGND VPWR VPWR _0453_ sky130_fd_sc_hd__a211oi_4
Xclkload2 clknet_2_3__leaf_clk VGND VGND VPWR VPWR clkload2/X sky130_fd_sc_hd__clkbuf_4
XFILLER_46_167 VGND VGND VPWR VPWR sky130_fd_sc_hd__fill_2
XFILLER_46_123 VGND VGND VPWR VPWR sky130_fd_sc_hd__decap_3
XFILLER_6_241 VGND VGND VPWR VPWR sky130_fd_sc_hd__decap_8
X_1213_ net70 _0307_ _0308_ VGND VGND VPWR VPWR _0310_ sky130_fd_sc_hd__or3_1
XTAP_TAPCELL_ROW_35_302 VGND VPWR sky130_fd_sc_hd__tapvpwrvgnd_1
X_1144_ _0202_ _0242_ VGND VGND VPWR VPWR _0243_ sky130_fd_sc_hd__xnor2_1
X_1075_ _0144_ _0151_ _0174_ VGND VGND VPWR VPWR _0176_ sky130_fd_sc_hd__and3_1
X_1977_ _0588_ _0096_ VGND VGND VPWR VPWR _0098_ sky130_fd_sc_hd__xnor2_1
XFILLER_28_101 VGND VGND VPWR VPWR sky130_fd_sc_hd__decap_6
XFILLER_45_57 VGND VGND VPWR VPWR sky130_fd_sc_hd__decap_4
XTAP_TAPCELL_ROW_41_338 VGND VPWR sky130_fd_sc_hd__tapvpwrvgnd_1
XFILLER_6_29 VGND VGND VPWR VPWR sky130_fd_sc_hd__decap_4
XFILLER_19_101 VGND VGND VPWR VPWR sky130_fd_sc_hd__decap_4
X_1831_ _0913_ _0914_ VGND VGND VPWR VPWR _0915_ sky130_fd_sc_hd__nor2_1
X_1900_ _0950_ _0957_ _0985_ net80 VGND VGND VPWR VPWR _0987_ sky130_fd_sc_hd__a31o_1
X_1693_ net121 net94 net33 VGND VGND VPWR VPWR _0777_ sky130_fd_sc_hd__a21oi_1
X_1762_ _0804_ _0806_ _0841_ _0842_ VGND VGND VPWR VPWR _0844_ sky130_fd_sc_hd__o211ai_2
X_1127_ net114 net98 VGND VGND VPWR VPWR _0226_ sky130_fd_sc_hd__nand2_1
XFILLER_15_16 VGND VGND VPWR VPWR sky130_fd_sc_hd__decap_4
X_1058_ net78 _0158_ _0159_ net86 VGND VGND VPWR VPWR _0005_ sky130_fd_sc_hd__o211a_1
XFILLER_33_192 VGND VGND VPWR VPWR sky130_fd_sc_hd__decap_4
Xoutput26 net26 VGND VGND VPWR VPWR acc_out[15] sky130_fd_sc_hd__buf_2
Xoutput37 net37 VGND VGND VPWR VPWR acc_out[25] sky130_fd_sc_hd__buf_2
XPHY_EDGE_ROW_1_Right_1 VGND VGND VPWR VPWR sky130_fd_sc_hd__decap_3
Xoutput48 net48 VGND VGND VPWR VPWR acc_out[6] sky130_fd_sc_hd__buf_2
XFILLER_0_225 VGND VGND VPWR VPWR sky130_fd_sc_hd__decap_8
XFILLER_16_126 VPWR VGND VPWR VGND sky130_ef_sc_hd__decap_12
X_2030_ clknet_2_1__leaf_clk _0021_ VGND VGND VPWR VPWR net30 sky130_fd_sc_hd__dfxtp_1
X_1814_ _0896_ _0897_ VGND VGND VPWR VPWR _0898_ sky130_fd_sc_hd__and2_1
X_1745_ _0825_ _0826_ _0797_ VGND VGND VPWR VPWR _0828_ sky130_fd_sc_hd__nand3b_1
X_1676_ net62 _0759_ _0760_ VGND VGND VPWR VPWR _0761_ sky130_fd_sc_hd__nand3_1
XPHY_EDGE_ROW_15_Left_67 VGND VGND VPWR VPWR sky130_fd_sc_hd__decap_3
XFILLER_38_251 VGND VGND VPWR VPWR sky130_fd_sc_hd__fill_1
XFILLER_26_37 VGND VGND VPWR VPWR sky130_fd_sc_hd__fill_2
XTAP_TAPCELL_ROW_51_400 VGND VPWR sky130_fd_sc_hd__tapvpwrvgnd_1
XTAP_TAPCELL_ROW_8_155 VGND VPWR sky130_fd_sc_hd__tapvpwrvgnd_1
XFILLER_8_100 VGND VGND VPWR VPWR sky130_fd_sc_hd__fill_1
X_1530_ _0580_ _0615_ VGND VGND VPWR VPWR _0619_ sky130_fd_sc_hd__nand2_1
X_1392_ _0437_ _0439_ _0483_ _0484_ VGND VGND VPWR VPWR _0485_ sky130_fd_sc_hd__o211a_1
X_1461_ _0471_ _0551_ VGND VGND VPWR VPWR _0552_ sky130_fd_sc_hd__nor2_2
X_2013_ clknet_2_0__leaf_clk _0004_ VGND VGND VPWR VPWR net42 sky130_fd_sc_hd__dfxtp_1
XFILLER_50_246 VGND VGND VPWR VPWR sky130_fd_sc_hd__decap_6
X_1728_ _0776_ _0778_ _0807_ _0808_ VGND VGND VPWR VPWR _0811_ sky130_fd_sc_hd__o211ai_1
X_1659_ net123 net95 net32 VGND VGND VPWR VPWR _0744_ sky130_fd_sc_hd__a21oi_1
XFILLER_37_36 VGND VGND VPWR VPWR sky130_fd_sc_hd__decap_4
XFILLER_26_265 VGND VGND VPWR VPWR sky130_fd_sc_hd__decap_3
XFILLER_26_243 VGND VGND VPWR VPWR sky130_fd_sc_hd__decap_8
XFILLER_26_221 VGND VGND VPWR VPWR sky130_fd_sc_hd__decap_4
XFILLER_41_257 VPWR VGND VPWR VGND sky130_ef_sc_hd__decap_12
XTAP_TAPCELL_ROW_19_216 VGND VPWR sky130_fd_sc_hd__tapvpwrvgnd_1
XTAP_TAPCELL_ROW_27_260 VGND VPWR sky130_fd_sc_hd__tapvpwrvgnd_1
X_1513_ _0601_ net58 _0602_ VGND VGND VPWR VPWR _0603_ sky130_fd_sc_hd__or3_4
X_1444_ _0522_ _0534_ _0535_ VGND VGND VPWR VPWR _0536_ sky130_fd_sc_hd__nand3_1
X_1375_ _0426_ _0428_ _0425_ VGND VGND VPWR VPWR _0468_ sky130_fd_sc_hd__a21oi_1
XFILLER_23_49 VGND VGND VPWR VPWR sky130_fd_sc_hd__decap_6
XFILLER_23_279 VGND VGND VPWR VPWR sky130_fd_sc_hd__fill_1
XPHY_EDGE_ROW_18_Left_70 VGND VGND VPWR VPWR sky130_fd_sc_hd__decap_3
XFILLER_14_235 VPWR VGND VPWR VGND sky130_ef_sc_hd__decap_12
XTAP_TAPCELL_ROW_24_241 VGND VPWR sky130_fd_sc_hd__tapvpwrvgnd_1
Xfanout94 net95 VGND VGND VPWR VPWR net94 sky130_fd_sc_hd__buf_2
Xfanout83 _0890_ VGND VGND VPWR VPWR net83 sky130_fd_sc_hd__clkbuf_2
Xfanout61 net62 VGND VGND VPWR VPWR net61 sky130_fd_sc_hd__buf_2
Xfanout72 net77 VGND VGND VPWR VPWR net72 sky130_fd_sc_hd__buf_4
XFILLER_1_183 VPWR VGND VPWR VGND sky130_ef_sc_hd__decap_12
X_1091_ _0166_ _0168_ _0189_ _0190_ VGND VGND VPWR VPWR _0191_ sky130_fd_sc_hd__o211ai_2
X_1160_ net114 net112 net97 net98 VGND VGND VPWR VPWR _0258_ sky130_fd_sc_hd__and4_1
XFILLER_20_227 VGND VGND VPWR VPWR sky130_fd_sc_hd__fill_1
XFILLER_20_238 VGND VGND VPWR VPWR sky130_fd_sc_hd__fill_1
X_1993_ _0111_ _0106_ _0105_ VGND VGND VPWR VPWR _0114_ sky130_fd_sc_hd__a21oi_2
XTAP_TAPCELL_ROW_30_277 VGND VPWR sky130_fd_sc_hd__tapvpwrvgnd_1
XFILLER_18_27 VGND VGND VPWR VPWR sky130_fd_sc_hd__fill_1
X_1358_ _0449_ _0450_ _0433_ VGND VGND VPWR VPWR _0452_ sky130_fd_sc_hd__a21oi_2
X_1427_ _0516_ _0517_ VGND VGND VPWR VPWR _0519_ sky130_fd_sc_hd__xnor2_1
XFILLER_43_308 VGND VGND VPWR VPWR sky130_fd_sc_hd__fill_1
XTAP_TAPCELL_ROW_38_322 VGND VPWR sky130_fd_sc_hd__tapvpwrvgnd_1
X_1289_ _0378_ _0383_ VGND VGND VPWR VPWR _0384_ sky130_fd_sc_hd__nand2b_1
XPHY_EDGE_ROW_3_Left_55 VGND VGND VPWR VPWR sky130_fd_sc_hd__decap_3
XFILLER_46_179 VGND VGND VPWR VPWR sky130_fd_sc_hd__fill_1
XFILLER_24_92 VPWR VGND VPWR VGND sky130_ef_sc_hd__decap_12
XFILLER_6_253 VPWR VGND VPWR VGND sky130_ef_sc_hd__decap_12
XFILLER_37_113 VGND VGND VPWR VPWR sky130_fd_sc_hd__fill_1
X_1212_ net70 _0307_ _0308_ VGND VGND VPWR VPWR _0309_ sky130_fd_sc_hd__nor3_1
XTAP_TAPCELL_ROW_35_303 VGND VPWR sky130_fd_sc_hd__tapvpwrvgnd_1
X_1143_ _0240_ _0241_ VGND VGND VPWR VPWR _0242_ sky130_fd_sc_hd__nand2b_1
XFILLER_1_85 VGND VGND VPWR VPWR sky130_fd_sc_hd__decap_3
X_1074_ _0144_ _0151_ _0174_ VGND VGND VPWR VPWR _0175_ sky130_fd_sc_hd__a21oi_1
X_1976_ _0094_ _0095_ VGND VGND VPWR VPWR _0096_ sky130_fd_sc_hd__nand2_1
XPHY_EDGE_ROW_45_Left_97 VGND VGND VPWR VPWR sky130_fd_sc_hd__decap_3
XFILLER_43_105 VGND VGND VPWR VPWR sky130_fd_sc_hd__decap_6
XFILLER_28_168 VGND VGND VPWR VPWR sky130_fd_sc_hd__decap_8
XTAP_TAPCELL_ROW_41_339 VGND VPWR sky130_fd_sc_hd__tapvpwrvgnd_1
XFILLER_3_223 VGND VGND VPWR VPWR sky130_fd_sc_hd__fill_1
XFILLER_10_61 VGND VGND VPWR VPWR sky130_fd_sc_hd__decap_3
XFILLER_34_105 VGND VGND VPWR VPWR sky130_fd_sc_hd__fill_1
XFILLER_19_146 VGND VGND VPWR VPWR sky130_fd_sc_hd__decap_6
X_1761_ _0841_ _0842_ _0804_ _0806_ VGND VGND VPWR VPWR _0843_ sky130_fd_sc_hd__a211o_1
X_1830_ net59 _0912_ VGND VGND VPWR VPWR _0914_ sky130_fd_sc_hd__and2_1
X_1692_ net33 net121 net94 VGND VGND VPWR VPWR _0776_ sky130_fd_sc_hd__and3_1
X_1126_ _0220_ _0224_ VGND VGND VPWR VPWR _0225_ sky130_fd_sc_hd__xnor2_1
X_1057_ net45 net82 VGND VGND VPWR VPWR _0159_ sky130_fd_sc_hd__or2_1
XFILLER_31_38 VGND VGND VPWR VPWR sky130_fd_sc_hd__fill_1
X_1959_ net56 _0077_ VGND VGND VPWR VPWR _0079_ sky130_fd_sc_hd__xnor2_1
Xoutput27 net27 VGND VGND VPWR VPWR acc_out[16] sky130_fd_sc_hd__buf_2
Xoutput38 net38 VGND VGND VPWR VPWR acc_out[26] sky130_fd_sc_hd__buf_2
Xoutput49 net49 VGND VGND VPWR VPWR acc_out[7] sky130_fd_sc_hd__buf_2
XFILLER_16_138 VGND VGND VPWR VPWR sky130_fd_sc_hd__fill_2
XFILLER_47_230 VPWR VGND VPWR VGND sky130_ef_sc_hd__decap_12
Xclkbuf_0_clk clk VGND VGND VPWR VPWR clknet_0_clk sky130_fd_sc_hd__clkbuf_16
X_1813_ _0858_ _0895_ VGND VGND VPWR VPWR _0897_ sky130_fd_sc_hd__or2_1
X_1744_ _0825_ _0826_ VGND VGND VPWR VPWR _0827_ sky130_fd_sc_hd__nand2b_1
X_1675_ _0756_ _0757_ _0758_ VGND VGND VPWR VPWR _0760_ sky130_fd_sc_hd__nand3_1
XPHY_EDGE_ROW_15_Right_15 VGND VGND VPWR VPWR sky130_fd_sc_hd__decap_3
XFILLER_38_274 VPWR VGND VPWR VGND sky130_ef_sc_hd__decap_12
X_1109_ _0207_ _0208_ VGND VGND VPWR VPWR _0209_ sky130_fd_sc_hd__and2b_1
XPHY_EDGE_ROW_24_Right_24 VGND VGND VPWR VPWR sky130_fd_sc_hd__decap_3
XFILLER_26_27 VGND VGND VPWR VPWR sky130_fd_sc_hd__fill_1
XPHY_EDGE_ROW_33_Right_33 VGND VGND VPWR VPWR sky130_fd_sc_hd__decap_3
XTAP_TAPCELL_ROW_8_156 VGND VPWR sky130_fd_sc_hd__tapvpwrvgnd_1
XPHY_EDGE_ROW_42_Right_42 VGND VGND VPWR VPWR sky130_fd_sc_hd__decap_3
XPHY_EDGE_ROW_32_Left_84 VGND VGND VPWR VPWR sky130_fd_sc_hd__decap_3
XFILLER_16_60 VGND VGND VPWR VPWR sky130_fd_sc_hd__decap_6
XPHY_EDGE_ROW_51_Right_51 VGND VGND VPWR VPWR sky130_fd_sc_hd__decap_3
XFILLER_12_141 VGND VGND VPWR VPWR sky130_fd_sc_hd__decap_6
X_1391_ _0480_ _0481_ net72 VGND VGND VPWR VPWR _0484_ sky130_fd_sc_hd__o21ai_1
X_1460_ _0469_ _0550_ VGND VGND VPWR VPWR _0551_ sky130_fd_sc_hd__xnor2_2
X_2012_ clknet_2_0__leaf_clk _0003_ VGND VGND VPWR VPWR net31 sky130_fd_sc_hd__dfxtp_1
X_1727_ _0776_ _0778_ _0807_ _0808_ VGND VGND VPWR VPWR _0810_ sky130_fd_sc_hd__o211a_1
X_1658_ net32 net121 net95 VGND VGND VPWR VPWR _0743_ sky130_fd_sc_hd__and3_1
XFILLER_12_29 VPWR VGND VPWR VGND sky130_ef_sc_hd__decap_12
X_1589_ _0675_ net146 VGND VGND VPWR VPWR _0677_ sky130_fd_sc_hd__nand2b_1
XTAP_TAPCELL_ROW_5_137 VGND VPWR sky130_fd_sc_hd__tapvpwrvgnd_1
XFILLER_41_225 VGND VGND VPWR VPWR sky130_fd_sc_hd__decap_6
XFILLER_41_214 VGND VGND VPWR VPWR sky130_fd_sc_hd__decap_8
XFILLER_41_269 VGND VGND VPWR VPWR sky130_fd_sc_hd__decap_8
XFILLER_5_159 VGND VGND VPWR VPWR sky130_fd_sc_hd__fill_2
XTAP_TAPCELL_ROW_19_217 VGND VPWR sky130_fd_sc_hd__tapvpwrvgnd_1
XFILLER_27_81 VGND VGND VPWR VPWR sky130_fd_sc_hd__decap_8
XTAP_TAPCELL_ROW_27_261 VGND VPWR sky130_fd_sc_hd__tapvpwrvgnd_1
X_1512_ _0599_ net173 _0600_ VGND VGND VPWR VPWR _0602_ sky130_fd_sc_hd__a21oi_4
X_1443_ _0531_ _0532_ _0533_ VGND VGND VPWR VPWR _0535_ sky130_fd_sc_hd__a21o_1
XFILLER_4_85 VGND VGND VPWR VPWR sky130_fd_sc_hd__fill_2
XFILLER_4_63 VGND VGND VPWR VPWR sky130_fd_sc_hd__fill_2
X_1374_ net22 net84 _0467_ net88 VGND VGND VPWR VPWR _0013_ sky130_fd_sc_hd__o211a_1
XFILLER_23_236 VGND VGND VPWR VPWR sky130_fd_sc_hd__fill_2
XFILLER_2_118 VGND VGND VPWR VPWR sky130_fd_sc_hd__fill_1
Xfanout73 net74 VGND VGND VPWR VPWR net73 sky130_fd_sc_hd__buf_8
Xfanout62 _0585_ VGND VGND VPWR VPWR net62 sky130_fd_sc_hd__clkbuf_2
XFILLER_14_247 VGND VGND VPWR VPWR sky130_fd_sc_hd__decap_4
XTAP_TAPCELL_ROW_24_242 VGND VPWR sky130_fd_sc_hd__tapvpwrvgnd_1
Xfanout95 net8 VGND VGND VPWR VPWR net95 sky130_fd_sc_hd__buf_4
Xfanout84 _0890_ VGND VGND VPWR VPWR net84 sky130_fd_sc_hd__buf_2
XFILLER_13_83 VGND VGND VPWR VPWR sky130_fd_sc_hd__fill_1
XFILLER_22_280 VGND VGND VPWR VPWR sky130_fd_sc_hd__decap_8
XFILLER_49_111 VGND VGND VPWR VPWR sky130_fd_sc_hd__fill_1
XFILLER_1_140 VGND VGND VPWR VPWR sky130_fd_sc_hd__decap_4
XFILLER_1_195 VPWR VGND VPWR VGND sky130_ef_sc_hd__decap_12
XFILLER_49_188 VGND VGND VPWR VPWR sky130_fd_sc_hd__decap_8
X_1090_ _0186_ _0187_ net114 net99 VGND VGND VPWR VPWR _0190_ sky130_fd_sc_hd__a2bb2o_1
XTAP_TAPCELL_ROW_30_278 VGND VPWR sky130_fd_sc_hd__tapvpwrvgnd_1
X_1992_ net79 _0112_ _0113_ net88 VGND VGND VPWR VPWR _0032_ sky130_fd_sc_hd__o211a_1
XTAP_TAPCELL_ROW_38_323 VGND VPWR sky130_fd_sc_hd__tapvpwrvgnd_1
XFILLER_18_39 VGND VGND VPWR VPWR sky130_fd_sc_hd__fill_1
X_1288_ _0381_ _0382_ VGND VGND VPWR VPWR _0383_ sky130_fd_sc_hd__xnor2_1
X_1357_ _0433_ _0449_ _0450_ VGND VGND VPWR VPWR _0451_ sky130_fd_sc_hd__and3_4
X_1426_ _0516_ _0517_ VGND VGND VPWR VPWR _0518_ sky130_fd_sc_hd__nand2_1
XFILLER_50_15 VPWR VGND VPWR VGND sky130_ef_sc_hd__decap_12
XFILLER_6_265 VPWR VGND VPWR VGND sky130_ef_sc_hd__decap_12
X_1142_ _0238_ _0239_ _0200_ _0205_ VGND VGND VPWR VPWR _0241_ sky130_fd_sc_hd__o211ai_2
X_1211_ net118 net169 net50 VGND VGND VPWR VPWR _0308_ sky130_fd_sc_hd__a21oi_1
XTAP_TAPCELL_ROW_35_304 VGND VPWR sky130_fd_sc_hd__tapvpwrvgnd_1
XFILLER_1_75 VGND VGND VPWR VPWR sky130_fd_sc_hd__fill_2
X_1073_ _0164_ _0173_ VGND VGND VPWR VPWR _0174_ sky130_fd_sc_hd__xnor2_1
X_1975_ _0064_ _0066_ _0093_ VGND VGND VPWR VPWR _0095_ sky130_fd_sc_hd__o21ai_1
X_1409_ _0453_ _0455_ _0500_ _0501_ VGND VGND VPWR VPWR _0502_ sky130_fd_sc_hd__o211a_1
XFILLER_45_15 VPWR VGND VPWR VGND sky130_ef_sc_hd__decap_12
XFILLER_3_279 VGND VGND VPWR VPWR sky130_fd_sc_hd__fill_1
XFILLER_10_95 VGND VGND VPWR VPWR sky130_fd_sc_hd__fill_1
XFILLER_42_161 VGND VGND VPWR VPWR sky130_fd_sc_hd__fill_1
XFILLER_42_150 VGND VGND VPWR VPWR sky130_fd_sc_hd__fill_2
XFILLER_19_169 VGND VGND VPWR VPWR sky130_fd_sc_hd__decap_4
XFILLER_51_91 VGND VGND VPWR VPWR sky130_fd_sc_hd__fill_1
X_1760_ _0838_ _0839_ net75 VGND VGND VPWR VPWR _0842_ sky130_fd_sc_hd__o21ai_1
X_1691_ net198 net83 _0775_ net86 VGND VGND VPWR VPWR _0022_ sky130_fd_sc_hd__o211a_1
XFILLER_42_194 VGND VGND VPWR VPWR sky130_fd_sc_hd__fill_2
XFILLER_32_3 VPWR VGND VPWR VGND sky130_ef_sc_hd__decap_12
X_1125_ _0222_ _0223_ VGND VGND VPWR VPWR _0224_ sky130_fd_sc_hd__and2b_1
XFILLER_33_150 VGND VGND VPWR VPWR sky130_fd_sc_hd__decap_4
X_1056_ _0156_ _0157_ VGND VGND VPWR VPWR _0158_ sky130_fd_sc_hd__nor2_1
Xoutput28 net28 VGND VGND VPWR VPWR acc_out[17] sky130_fd_sc_hd__buf_2
X_1889_ net60 _0938_ _0939_ VGND VGND VPWR VPWR _0975_ sky130_fd_sc_hd__o21a_1
Xoutput39 net39 VGND VGND VPWR VPWR acc_out[27] sky130_fd_sc_hd__buf_2
X_1958_ net63 _0077_ VGND VGND VPWR VPWR _0078_ sky130_fd_sc_hd__and2_1
XFILLER_48_209 VGND VGND VPWR VPWR sky130_fd_sc_hd__decap_6
XFILLER_0_238 VGND VGND VPWR VPWR sky130_fd_sc_hd__decap_8
XFILLER_12_301 VGND VGND VPWR VPWR sky130_fd_sc_hd__decap_3
XFILLER_47_242 VPWR VGND VPWR VGND sky130_ef_sc_hd__decap_12
XFILLER_47_220 VGND VGND VPWR VPWR sky130_fd_sc_hd__decap_4
XFILLER_46_80 VGND VGND VPWR VPWR sky130_fd_sc_hd__decap_4
X_1674_ _0756_ _0757_ _0758_ VGND VGND VPWR VPWR _0759_ sky130_fd_sc_hd__a21o_1
X_1743_ _0822_ _0823_ _0824_ VGND VGND VPWR VPWR _0826_ sky130_fd_sc_hd__a21o_1
X_1812_ _0858_ _0895_ VGND VGND VPWR VPWR _0896_ sky130_fd_sc_hd__nand2_1
XFILLER_30_175 VGND VGND VPWR VPWR sky130_fd_sc_hd__decap_3
XFILLER_38_286 VGND VGND VPWR VPWR sky130_fd_sc_hd__fill_2
XFILLER_38_253 VGND VGND VPWR VPWR sky130_fd_sc_hd__decap_8
X_1108_ _0205_ _0206_ _0175_ _0177_ VGND VGND VPWR VPWR _0208_ sky130_fd_sc_hd__a211o_1
X_1039_ net114 net103 _0138_ _0139_ VGND VGND VPWR VPWR _0141_ sky130_fd_sc_hd__o2bb2a_1
XFILLER_42_27 VGND VGND VPWR VPWR sky130_fd_sc_hd__fill_1
XFILLER_21_164 VGND VGND VPWR VPWR sky130_fd_sc_hd__decap_4
XFILLER_21_197 VGND VGND VPWR VPWR sky130_fd_sc_hd__decap_8
XTAP_TAPCELL_ROW_8_157 VGND VPWR sky130_fd_sc_hd__tapvpwrvgnd_1
XFILLER_12_131 VGND VGND VPWR VPWR sky130_fd_sc_hd__decap_8
XFILLER_8_179 VPWR VGND VPWR VGND sky130_ef_sc_hd__decap_12
X_1390_ net72 _0480_ _0481_ VGND VGND VPWR VPWR _0483_ sky130_fd_sc_hd__or3_4
X_2011_ clknet_2_0__leaf_clk _0002_ VGND VGND VPWR VPWR net20 sky130_fd_sc_hd__dfxtp_1
XTAP_TAPCELL_ROW_13_181 VGND VPWR sky130_fd_sc_hd__tapvpwrvgnd_1
X_1726_ _0807_ _0808_ _0776_ _0778_ VGND VGND VPWR VPWR _0809_ sky130_fd_sc_hd__a211o_1
X_1657_ net201 net83 _0741_ _0742_ net87 VGND VGND VPWR VPWR _0021_ sky130_fd_sc_hd__o221a_1
X_1588_ net147 _0674_ _0645_ VGND VGND VPWR VPWR _0676_ sky130_fd_sc_hd__o21bai_4
XTAP_TAPCELL_ROW_5_138 VGND VPWR sky130_fd_sc_hd__tapvpwrvgnd_1
XFILLER_26_278 VGND VGND VPWR VPWR sky130_fd_sc_hd__fill_1
XFILLER_5_149 VGND VGND VPWR VPWR sky130_fd_sc_hd__decap_6
XFILLER_17_223 VGND VGND VPWR VPWR sky130_fd_sc_hd__fill_1
XTAP_TAPCELL_ROW_19_218 VGND VPWR sky130_fd_sc_hd__tapvpwrvgnd_1
Xclkbuf_2_0__f_clk clknet_0_clk VGND VGND VPWR VPWR clknet_2_0__leaf_clk sky130_fd_sc_hd__clkbuf_16
XTAP_TAPCELL_ROW_27_262 VGND VPWR sky130_fd_sc_hd__tapvpwrvgnd_1
X_1511_ _0599_ _0598_ _0600_ VGND VGND VPWR VPWR _0601_ sky130_fd_sc_hd__and3_1
X_1442_ _0531_ _0532_ _0533_ VGND VGND VPWR VPWR _0534_ sky130_fd_sc_hd__nand3_1
XFILLER_4_97 VGND VGND VPWR VPWR sky130_fd_sc_hd__fill_2
X_1373_ net79 _0465_ _0466_ VGND VGND VPWR VPWR _0467_ sky130_fd_sc_hd__or3_1
XFILLER_31_281 VGND VGND VPWR VPWR sky130_fd_sc_hd__decap_4
XFILLER_23_29 VPWR VGND VPWR VGND sky130_ef_sc_hd__decap_12
XFILLER_48_15 VPWR VGND VPWR VGND sky130_ef_sc_hd__decap_12
X_1709_ _0789_ _0790_ _0791_ VGND VGND VPWR VPWR _0793_ sky130_fd_sc_hd__nand3_1
XFILLER_46_307 VGND VGND VPWR VPWR sky130_fd_sc_hd__fill_1
Xfanout85 _0890_ VGND VGND VPWR VPWR net85 sky130_fd_sc_hd__buf_2
Xfanout63 _0585_ VGND VGND VPWR VPWR net63 sky130_fd_sc_hd__clkbuf_4
Xfanout74 net77 VGND VGND VPWR VPWR net74 sky130_fd_sc_hd__buf_8
Xfanout96 net97 VGND VGND VPWR VPWR net96 sky130_fd_sc_hd__clkbuf_2
XTAP_TAPCELL_ROW_24_243 VGND VPWR sky130_fd_sc_hd__tapvpwrvgnd_1
XFILLER_29_9 VPWR VGND VPWR VGND sky130_ef_sc_hd__decap_12
XFILLER_1_152 VGND VGND VPWR VPWR sky130_fd_sc_hd__fill_2
XTAP_TAPCELL_ROW_47_368 VGND VPWR sky130_fd_sc_hd__tapvpwrvgnd_1
XTAP_TAPCELL_ROW_30_279 VGND VPWR sky130_fd_sc_hd__tapvpwrvgnd_1
XFILLER_9_241 VPWR VGND VPWR VGND sky130_ef_sc_hd__decap_12
XFILLER_13_281 VPWR VGND VPWR VGND sky130_ef_sc_hd__decap_12
XFILLER_20_207 VPWR VGND VPWR VGND sky130_ef_sc_hd__decap_12
X_1991_ net43 net84 VGND VGND VPWR VPWR _0113_ sky130_fd_sc_hd__or2_1
X_1425_ net97 _0868_ VGND VGND VPWR VPWR _0517_ sky130_fd_sc_hd__nor2_1
X_1287_ net101 _0868_ VGND VGND VPWR VPWR _0382_ sky130_fd_sc_hd__nor2_1
X_1356_ _0445_ _0446_ _0447_ VGND VGND VPWR VPWR _0450_ sky130_fd_sc_hd__a21o_1
XFILLER_11_207 VGND VGND VPWR VPWR sky130_fd_sc_hd__fill_1
XFILLER_50_27 VGND VGND VPWR VPWR sky130_fd_sc_hd__fill_1
XFILLER_10_251 VGND VGND VPWR VPWR sky130_fd_sc_hd__fill_1
XFILLER_40_93 VGND VGND VPWR VPWR sky130_fd_sc_hd__fill_2
XFILLER_6_277 VPWR VGND VPWR VGND sky130_ef_sc_hd__decap_12
X_1141_ _0200_ _0205_ _0238_ _0239_ VGND VGND VPWR VPWR _0240_ sky130_fd_sc_hd__a211oi_1
X_1072_ _0171_ _0172_ VGND VGND VPWR VPWR _0173_ sky130_fd_sc_hd__and2b_1
X_1210_ net50 net118 net90 VGND VGND VPWR VPWR _0307_ sky130_fd_sc_hd__and3_4
XFILLER_45_181 VPWR VGND VPWR VGND sky130_ef_sc_hd__decap_12
XTAP_TAPCELL_ROW_35_305 VGND VPWR sky130_fd_sc_hd__tapvpwrvgnd_1
X_1974_ _0064_ _0066_ _0093_ VGND VGND VPWR VPWR _0094_ sky130_fd_sc_hd__or3_1
X_1408_ _0497_ _0499_ _0430_ _0432_ VGND VGND VPWR VPWR _0501_ sky130_fd_sc_hd__o211ai_1
XFILLER_45_27 VPWR VGND VPWR VGND sky130_ef_sc_hd__decap_12
X_1339_ _0423_ _0431_ VGND VGND VPWR VPWR _0433_ sky130_fd_sc_hd__xnor2_1
XFILLER_51_162 VGND VGND VPWR VPWR sky130_fd_sc_hd__fill_2
XFILLER_3_225 VPWR VGND VPWR VGND sky130_ef_sc_hd__decap_12
XFILLER_10_41 VPWR VGND VPWR VGND sky130_ef_sc_hd__decap_12
XFILLER_35_93 VGND VGND VPWR VPWR sky130_fd_sc_hd__fill_1
XFILLER_51_81 VGND VGND VPWR VPWR sky130_fd_sc_hd__decap_3
X_1690_ _0773_ _0774_ net78 VGND VGND VPWR VPWR _0775_ sky130_fd_sc_hd__a21o_1
XTAP_TAPCELL_ROW_40_330 VGND VPWR sky130_fd_sc_hd__tapvpwrvgnd_1
XFILLER_25_3 VGND VGND VPWR VPWR sky130_fd_sc_hd__fill_1
X_1124_ net100 net111 net99 net165 VGND VGND VPWR VPWR _0223_ sky130_fd_sc_hd__a22o_1
X_1055_ _0154_ _0155_ _0135_ VGND VGND VPWR VPWR _0157_ sky130_fd_sc_hd__a21oi_1
XFILLER_33_184 VGND VGND VPWR VPWR sky130_fd_sc_hd__decap_4
XFILLER_31_18 VPWR VGND VPWR VGND sky130_ef_sc_hd__decap_12
X_1957_ _0074_ _0075_ VGND VGND VPWR VPWR _0077_ sky130_fd_sc_hd__nor2_1
Xoutput29 net29 VGND VGND VPWR VPWR acc_out[18] sky130_fd_sc_hd__buf_2
X_1888_ _0588_ _0971_ VGND VGND VPWR VPWR _0974_ sky130_fd_sc_hd__xnor2_1
XFILLER_0_217 VGND VGND VPWR VPWR sky130_fd_sc_hd__decap_6
XFILLER_24_195 VGND VGND VPWR VPWR sky130_fd_sc_hd__fill_1
XFILLER_21_40 VGND VGND VPWR VPWR sky130_fd_sc_hd__fill_1
XFILLER_47_254 VPWR VGND VPWR VGND sky130_ef_sc_hd__decap_12
X_1811_ _0893_ _0894_ VGND VGND VPWR VPWR _0895_ sky130_fd_sc_hd__nor2_1
XFILLER_15_140 VGND VGND VPWR VPWR sky130_fd_sc_hd__fill_1
X_1673_ net57 _0725_ _0726_ VGND VGND VPWR VPWR _0758_ sky130_fd_sc_hd__o21bai_1
X_1742_ _0822_ _0823_ _0824_ VGND VGND VPWR VPWR _0825_ sky130_fd_sc_hd__and3_1
XPHY_EDGE_ROW_5_Right_5 VGND VGND VPWR VPWR sky130_fd_sc_hd__decap_3
X_1107_ _0175_ _0177_ _0205_ _0206_ VGND VGND VPWR VPWR _0207_ sky130_fd_sc_hd__o211a_1
X_1038_ _0138_ _0139_ net114 net103 VGND VGND VPWR VPWR _0140_ sky130_fd_sc_hd__and4bb_1
XTAP_TAPCELL_ROW_8_158 VGND VPWR sky130_fd_sc_hd__tapvpwrvgnd_1
XFILLER_29_276 VGND VGND VPWR VPWR sky130_fd_sc_hd__fill_1
XFILLER_16_73 VGND VGND VPWR VPWR sky130_fd_sc_hd__decap_3
XFILLER_32_61 VGND VGND VPWR VPWR sky130_fd_sc_hd__decap_8
XFILLER_8_158 VPWR VGND VPWR VGND sky130_ef_sc_hd__decap_12
X_2010_ clknet_2_1__leaf_clk _0001_ VGND VGND VPWR VPWR net52 sky130_fd_sc_hd__dfxtp_1
XFILLER_35_279 VGND VGND VPWR VPWR sky130_fd_sc_hd__fill_1
XFILLER_35_268 VGND VGND VPWR VPWR sky130_fd_sc_hd__decap_3
X_1725_ _0804_ _0805_ net76 VGND VGND VPWR VPWR _0808_ sky130_fd_sc_hd__o21ai_1
XTAP_TAPCELL_ROW_13_182 VGND VPWR sky130_fd_sc_hd__tapvpwrvgnd_1
X_1656_ net83 _0740_ VGND VGND VPWR VPWR _0742_ sky130_fd_sc_hd__nand2_1
X_1587_ net147 _0674_ _0645_ VGND VGND VPWR VPWR _0675_ sky130_fd_sc_hd__nor3b_1
XFILLER_7_191 VGND VGND VPWR VPWR sky130_fd_sc_hd__fill_1
XTAP_TAPCELL_ROW_5_139 VGND VPWR sky130_fd_sc_hd__tapvpwrvgnd_1
XFILLER_41_205 VGND VGND VPWR VPWR sky130_fd_sc_hd__decap_4
XFILLER_5_117 VGND VGND VPWR VPWR sky130_fd_sc_hd__fill_1
XFILLER_49_305 VGND VGND VPWR VPWR sky130_fd_sc_hd__decap_4
XFILLER_17_279 VGND VGND VPWR VPWR sky130_fd_sc_hd__fill_1
XFILLER_43_93 VGND VGND VPWR VPWR sky130_fd_sc_hd__fill_2
X_1510_ _0561_ net67 _0562_ VGND VGND VPWR VPWR _0600_ sky130_fd_sc_hd__a21o_1
XFILLER_4_43 VPWR VGND VPWR VGND sky130_ef_sc_hd__decap_12
X_1441_ net68 _0487_ _0485_ VGND VGND VPWR VPWR _0533_ sky130_fd_sc_hd__a21o_1
X_1372_ _0416_ _0464_ _0463_ VGND VGND VPWR VPWR _0466_ sky130_fd_sc_hd__o21a_1
XFILLER_31_260 VGND VGND VPWR VPWR sky130_fd_sc_hd__decap_3
X_1708_ _0789_ _0790_ _0791_ VGND VGND VPWR VPWR _0792_ sky130_fd_sc_hd__a21o_1
XFILLER_48_27 VGND VGND VPWR VPWR sky130_fd_sc_hd__fill_1
X_1639_ _0722_ _0723_ _0724_ VGND VGND VPWR VPWR _0725_ sky130_fd_sc_hd__a21oi_1
XFILLER_14_216 VGND VGND VPWR VPWR sky130_fd_sc_hd__decap_4
Xfanout75 net76 VGND VGND VPWR VPWR net75 sky130_fd_sc_hd__clkbuf_2
Xfanout86 _0879_ VGND VGND VPWR VPWR net86 sky130_fd_sc_hd__clkbuf_4
Xfanout64 net65 VGND VGND VPWR VPWR net64 sky130_fd_sc_hd__buf_8
XFILLER_13_63 VGND VGND VPWR VPWR sky130_fd_sc_hd__fill_1
Xfanout97 net7 VGND VGND VPWR VPWR net97 sky130_fd_sc_hd__clkbuf_2
XTAP_TAPCELL_ROW_24_244 VGND VPWR sky130_fd_sc_hd__tapvpwrvgnd_1
XFILLER_49_135 VGND VGND VPWR VPWR sky130_fd_sc_hd__decap_6
XFILLER_49_113 VPWR VGND VPWR VGND sky130_ef_sc_hd__decap_12
XFILLER_37_308 VGND VGND VPWR VPWR sky130_fd_sc_hd__fill_1
XTAP_TAPCELL_ROW_47_369 VGND VPWR sky130_fd_sc_hd__tapvpwrvgnd_1
XFILLER_20_219 VGND VGND VPWR VPWR sky130_fd_sc_hd__decap_8
X_1990_ _0107_ _0111_ VGND VGND VPWR VPWR _0112_ sky130_fd_sc_hd__xnor2_1
XFILLER_9_220 VGND VGND VPWR VPWR sky130_fd_sc_hd__decap_4
XFILLER_9_253 VPWR VGND VPWR VGND sky130_ef_sc_hd__decap_12
XFILLER_13_293 VPWR VGND VPWR VGND sky130_ef_sc_hd__decap_12
XPHY_EDGE_ROW_50_Left_102 VGND VGND VPWR VPWR sky130_fd_sc_hd__decap_3
X_1355_ _0445_ _0446_ _0447_ VGND VGND VPWR VPWR _0449_ sky130_fd_sc_hd__nand3_1
X_1424_ _0471_ _0515_ VGND VGND VPWR VPWR _0516_ sky130_fd_sc_hd__nor2_1
X_1286_ _0379_ _0380_ VGND VGND VPWR VPWR _0381_ sky130_fd_sc_hd__nand2b_1
XFILLER_34_29 VGND VGND VPWR VPWR sky130_fd_sc_hd__fill_2
XTAP_TAPCELL_ROW_21_225 VGND VPWR sky130_fd_sc_hd__tapvpwrvgnd_1
XFILLER_46_149 VGND VGND VPWR VPWR sky130_fd_sc_hd__decap_3
XFILLER_42_300 VGND VGND VPWR VPWR sky130_fd_sc_hd__decap_8
XFILLER_24_62 VGND VGND VPWR VPWR sky130_fd_sc_hd__fill_2
XFILLER_49_81 VGND VGND VPWR VPWR sky130_fd_sc_hd__fill_1
XFILLER_6_289 VPWR VGND VPWR VGND sky130_ef_sc_hd__decap_12
XFILLER_27_7 VGND VGND VPWR VPWR sky130_fd_sc_hd__fill_1
XTAP_TAPCELL_ROW_35_306 VGND VPWR sky130_fd_sc_hd__tapvpwrvgnd_1
X_1140_ _0236_ _0237_ _0219_ VGND VGND VPWR VPWR _0239_ sky130_fd_sc_hd__a21oi_1
X_1071_ _0169_ _0170_ _0139_ _0140_ VGND VGND VPWR VPWR _0172_ sky130_fd_sc_hd__a211o_1
XFILLER_45_193 VPWR VGND VPWR VGND sky130_ef_sc_hd__decap_12
XTAP_TAPCELL_ROW_43_350 VGND VPWR sky130_fd_sc_hd__tapvpwrvgnd_1
X_1973_ net68 _0092_ VGND VGND VPWR VPWR _0093_ sky130_fd_sc_hd__xnor2_1
XFILLER_29_29 VGND VGND VPWR VPWR sky130_fd_sc_hd__fill_2
X_1338_ _0423_ _0431_ VGND VGND VPWR VPWR _0432_ sky130_fd_sc_hd__nand2b_1
X_1407_ _0430_ _0432_ _0499_ _0497_ VGND VGND VPWR VPWR _0500_ sky130_fd_sc_hd__a211o_4
XFILLER_51_141 VGND VGND VPWR VPWR sky130_fd_sc_hd__fill_1
XFILLER_45_39 VPWR VGND VPWR VGND sky130_ef_sc_hd__decap_12
X_1269_ _0361_ _0362_ _0345_ VGND VGND VPWR VPWR _0365_ sky130_fd_sc_hd__a21oi_1
XPHY_EDGE_ROW_7_Left_59 VGND VGND VPWR VPWR sky130_fd_sc_hd__decap_3
XFILLER_3_237 VPWR VGND VPWR VGND sky130_ef_sc_hd__decap_12
XFILLER_10_53 VGND VGND VPWR VPWR sky130_fd_sc_hd__decap_8
XFILLER_19_40 VGND VGND VPWR VPWR sky130_fd_sc_hd__fill_1
XFILLER_19_51 VGND VGND VPWR VPWR sky130_fd_sc_hd__decap_4
XFILLER_42_185 VGND VGND VPWR VPWR sky130_fd_sc_hd__fill_2
XTAP_TAPCELL_ROW_40_331 VGND VPWR sky130_fd_sc_hd__tapvpwrvgnd_1
XFILLER_35_50 VGND VGND VPWR VPWR sky130_fd_sc_hd__decap_6
XFILLER_30_303 VGND VGND VPWR VPWR sky130_fd_sc_hd__fill_1
X_1123_ net165 net100 net111 net99 VGND VGND VPWR VPWR _0222_ sky130_fd_sc_hd__and4_1
X_1054_ _0135_ _0154_ _0155_ VGND VGND VPWR VPWR _0156_ sky130_fd_sc_hd__and3_1
X_1887_ net59 _0971_ VGND VGND VPWR VPWR _0973_ sky130_fd_sc_hd__nor2_1
X_1956_ _1001_ _1003_ _0073_ VGND VGND VPWR VPWR _0075_ sky130_fd_sc_hd__o21a_1
XFILLER_8_307 VGND VGND VPWR VPWR sky130_fd_sc_hd__fill_1
XFILLER_24_174 VGND VGND VPWR VPWR sky130_fd_sc_hd__fill_2
XFILLER_47_266 VPWR VGND VPWR VGND sky130_ef_sc_hd__decap_12
X_1810_ _0891_ _0892_ VGND VGND VPWR VPWR _0894_ sky130_fd_sc_hd__and2b_1
X_1741_ _0793_ _0794_ VGND VGND VPWR VPWR _0824_ sky130_fd_sc_hd__nand2_1
XFILLER_7_54 VGND VGND VPWR VPWR sky130_fd_sc_hd__fill_2
X_1672_ _0754_ _0755_ net58 VGND VGND VPWR VPWR _0757_ sky130_fd_sc_hd__o21ai_1
X_1106_ _0200_ _0201_ _0204_ VGND VGND VPWR VPWR _0206_ sky130_fd_sc_hd__a21o_1
X_1037_ net45 net116 net100 VGND VGND VPWR VPWR _0139_ sky130_fd_sc_hd__and3_1
XFILLER_21_111 VGND VGND VPWR VPWR sky130_fd_sc_hd__fill_1
XFILLER_21_144 VGND VGND VPWR VPWR sky130_fd_sc_hd__fill_1
X_1939_ net41 net118 net158 VGND VGND VPWR VPWR _0058_ sky130_fd_sc_hd__and3_1
XFILLER_21_188 VGND VGND VPWR VPWR sky130_fd_sc_hd__decap_3
XFILLER_44_236 VPWR VGND VPWR VGND sky130_ef_sc_hd__decap_12
XFILLER_8_137 VGND VGND VPWR VPWR sky130_fd_sc_hd__decap_3
XPHY_EDGE_ROW_11_Right_11 VGND VGND VPWR VPWR sky130_fd_sc_hd__decap_3
XFILLER_12_100 VGND VGND VPWR VPWR sky130_fd_sc_hd__decap_4
XFILLER_12_166 VPWR VGND VPWR VGND sky130_ef_sc_hd__decap_12
XFILLER_12_188 VGND VGND VPWR VPWR sky130_fd_sc_hd__decap_8
XPHY_EDGE_ROW_20_Right_20 VGND VGND VPWR VPWR sky130_fd_sc_hd__decap_3
XFILLER_35_225 VGND VGND VPWR VPWR sky130_fd_sc_hd__fill_1
X_1724_ net75 _0804_ _0805_ VGND VGND VPWR VPWR _0807_ sky130_fd_sc_hd__or3_1
XTAP_TAPCELL_ROW_13_183 VGND VPWR sky130_fd_sc_hd__tapvpwrvgnd_1
X_1655_ _0705_ _0711_ _0739_ VGND VGND VPWR VPWR _0741_ sky130_fd_sc_hd__and3_1
X_1586_ _0670_ _0671_ _0672_ VGND VGND VPWR VPWR _0674_ sky130_fd_sc_hd__a21oi_1
XFILLER_26_225 VGND VGND VPWR VPWR sky130_fd_sc_hd__fill_1
XFILLER_41_239 VPWR VGND VPWR VGND sky130_ef_sc_hd__decap_12
XPHY_EDGE_ROW_36_Left_88 VGND VGND VPWR VPWR sky130_fd_sc_hd__decap_3
XFILLER_17_203 VGND VGND VPWR VPWR sky130_fd_sc_hd__decap_4
XFILLER_17_214 VGND VGND VPWR VPWR sky130_fd_sc_hd__decap_6
XFILLER_17_247 VPWR VGND VPWR VGND sky130_ef_sc_hd__decap_12
XFILLER_27_51 VGND VGND VPWR VPWR sky130_fd_sc_hd__decap_4
XTAP_TAPCELL_ROW_10_164 VGND VPWR sky130_fd_sc_hd__tapvpwrvgnd_1
X_1440_ _0528_ _0530_ net68 VGND VGND VPWR VPWR _0532_ sky130_fd_sc_hd__a21o_1
XFILLER_4_195 VGND VGND VPWR VPWR sky130_fd_sc_hd__fill_1
XFILLER_4_173 VPWR VGND VPWR VGND sky130_ef_sc_hd__decap_12
XFILLER_4_77 VGND VGND VPWR VPWR sky130_fd_sc_hd__fill_1
XFILLER_4_55 VGND VGND VPWR VPWR sky130_fd_sc_hd__decap_8
XFILLER_4_22 VGND VGND VPWR VPWR sky130_fd_sc_hd__decap_6
XFILLER_4_11 VGND VGND VPWR VPWR sky130_fd_sc_hd__decap_3
X_1371_ _0416_ _0463_ _0464_ VGND VGND VPWR VPWR _0465_ sky130_fd_sc_hd__nor3_1
XFILLER_23_228 VGND VGND VPWR VPWR sky130_fd_sc_hd__decap_8
X_1707_ net58 _0754_ _0755_ VGND VGND VPWR VPWR _0791_ sky130_fd_sc_hd__o21bai_1
X_1638_ net66 _0686_ _0687_ VGND VGND VPWR VPWR _0724_ sky130_fd_sc_hd__a21o_1
X_1569_ _0655_ _0656_ _0624_ _0626_ VGND VGND VPWR VPWR _0657_ sky130_fd_sc_hd__a211o_1
Xfanout87 _0879_ VGND VGND VPWR VPWR net87 sky130_fd_sc_hd__clkbuf_2
Xfanout65 _0436_ VGND VGND VPWR VPWR net65 sky130_fd_sc_hd__buf_8
Xfanout76 net77 VGND VGND VPWR VPWR net76 sky130_fd_sc_hd__clkbuf_2
XFILLER_13_75 VGND VGND VPWR VPWR sky130_fd_sc_hd__decap_8
Xfanout98 net6 VGND VGND VPWR VPWR net98 sky130_fd_sc_hd__clkbuf_2
XTAP_TAPCELL_ROW_24_245 VGND VPWR sky130_fd_sc_hd__tapvpwrvgnd_1
XFILLER_49_103 VGND VGND VPWR VPWR sky130_fd_sc_hd__decap_8
XFILLER_49_169 VGND VGND VPWR VPWR sky130_fd_sc_hd__decap_6
XFILLER_49_147 VPWR VGND VPWR VGND sky130_ef_sc_hd__decap_12
XFILLER_13_261 VPWR VGND VPWR VGND sky130_ef_sc_hd__decap_12
XFILLER_9_265 VPWR VGND VPWR VGND sky130_ef_sc_hd__decap_12
XFILLER_48_3 VPWR VGND VPWR VGND sky130_ef_sc_hd__decap_12
X_1285_ net6 net109 net106 net5 VGND VGND VPWR VPWR _0380_ sky130_fd_sc_hd__a22o_1
X_1354_ _0445_ _0446_ _0447_ VGND VGND VPWR VPWR _0448_ sky130_fd_sc_hd__and3_1
X_1423_ net109 net107 net132 VGND VGND VPWR VPWR _0515_ sky130_fd_sc_hd__o21ai_1
XFILLER_50_29 VPWR VGND VPWR VGND sky130_ef_sc_hd__decap_12
XTAP_TAPCELL_ROW_21_226 VGND VPWR sky130_fd_sc_hd__tapvpwrvgnd_1
XFILLER_46_117 VGND VGND VPWR VPWR sky130_fd_sc_hd__fill_1
XFILLER_39_180 VGND VGND VPWR VPWR sky130_fd_sc_hd__decap_4
XFILLER_6_202 VGND VGND VPWR VPWR sky130_fd_sc_hd__fill_2
XFILLER_10_253 VPWR VGND VPWR VGND sky130_ef_sc_hd__decap_12
XPHY_EDGE_ROW_39_Left_91 VGND VGND VPWR VPWR sky130_fd_sc_hd__decap_3
X_1070_ _0139_ _0140_ _0169_ _0170_ VGND VGND VPWR VPWR _0171_ sky130_fd_sc_hd__o211a_1
X_1972_ _0090_ _0091_ VGND VGND VPWR VPWR _0092_ sky130_fd_sc_hd__nand2_1
XPHY_EDGE_ROW_23_Left_75 VGND VGND VPWR VPWR sky130_fd_sc_hd__decap_3
XPHY_EDGE_ROW_49_Right_49 VGND VGND VPWR VPWR sky130_fd_sc_hd__decap_3
XFILLER_28_139 VGND VGND VPWR VPWR sky130_fd_sc_hd__fill_1
X_1268_ _0345_ _0361_ net157 VGND VGND VPWR VPWR _0364_ sky130_fd_sc_hd__nand3_1
X_1337_ _0424_ _0429_ VGND VGND VPWR VPWR _0431_ sky130_fd_sc_hd__xor2_1
X_1406_ _0495_ _0496_ _0448_ _0451_ VGND VGND VPWR VPWR _0499_ sky130_fd_sc_hd__a211oi_2
XFILLER_51_197 VGND VGND VPWR VPWR sky130_fd_sc_hd__decap_8
XFILLER_51_175 VPWR VGND VPWR VGND sky130_ef_sc_hd__decap_12
XFILLER_36_161 VGND VGND VPWR VPWR sky130_fd_sc_hd__fill_1
X_1199_ _0294_ _0295_ VGND VGND VPWR VPWR _0296_ sky130_fd_sc_hd__xor2_1
XFILLER_3_205 VPWR VGND VPWR VGND sky130_ef_sc_hd__decap_12
XFILLER_3_249 VPWR VGND VPWR VGND sky130_ef_sc_hd__decap_12
XTAP_TAPCELL_ROW_40_332 VGND VPWR sky130_fd_sc_hd__tapvpwrvgnd_1
XFILLER_35_73 VGND VGND VPWR VPWR sky130_fd_sc_hd__fill_2
X_1122_ net111 net99 VGND VGND VPWR VPWR _0221_ sky130_fd_sc_hd__nand2_1
X_1053_ _0130_ _0132_ _0153_ VGND VGND VPWR VPWR _0155_ sky130_fd_sc_hd__nand3_1
X_1886_ _0969_ _0970_ VGND VGND VPWR VPWR _0971_ sky130_fd_sc_hd__xnor2_1
X_1955_ _1001_ _1003_ _0073_ VGND VGND VPWR VPWR _0074_ sky130_fd_sc_hd__nor3_1
XFILLER_24_197 VGND VGND VPWR VPWR sky130_fd_sc_hd__decap_4
XFILLER_47_278 VGND VGND VPWR VPWR sky130_fd_sc_hd__fill_2
XFILLER_30_112 VGND VGND VPWR VPWR sky130_fd_sc_hd__fill_1
XFILLER_15_120 VPWR VGND VPWR VGND sky130_ef_sc_hd__decap_12
X_1671_ net58 _0754_ _0755_ VGND VGND VPWR VPWR _0756_ sky130_fd_sc_hd__or3_1
X_1740_ _0820_ _0821_ _0585_ VGND VGND VPWR VPWR _0823_ sky130_fd_sc_hd__a21o_1
XFILLER_30_3 VGND VGND VPWR VPWR sky130_fd_sc_hd__fill_1
XFILLER_7_99 VGND VGND VPWR VPWR sky130_fd_sc_hd__fill_1
XFILLER_38_201 VGND VGND VPWR VPWR sky130_fd_sc_hd__fill_1
X_1105_ _0200_ _0201_ _0204_ VGND VGND VPWR VPWR _0205_ sky130_fd_sc_hd__nand3_2
X_1036_ net116 net100 net45 VGND VGND VPWR VPWR _0138_ sky130_fd_sc_hd__a21oi_1
X_1869_ _0858_ _0895_ _0924_ _0893_ VGND VGND VPWR VPWR _0954_ sky130_fd_sc_hd__a22o_1
X_1938_ net79 _0055_ _0057_ net89 VGND VGND VPWR VPWR _0030_ sky130_fd_sc_hd__o211a_1
XFILLER_29_212 VGND VGND VPWR VPWR sky130_fd_sc_hd__fill_1
XPHY_EDGE_ROW_10_Left_62 VGND VGND VPWR VPWR sky130_fd_sc_hd__decap_3
XFILLER_44_259 VGND VGND VPWR VPWR sky130_fd_sc_hd__fill_1
XFILLER_44_248 VGND VGND VPWR VPWR sky130_fd_sc_hd__decap_4
XFILLER_29_256 VPWR VGND VPWR VGND sky130_ef_sc_hd__decap_12
XFILLER_16_20 VGND VGND VPWR VPWR sky130_fd_sc_hd__decap_4
XFILLER_32_85 VGND VGND VPWR VPWR sky130_fd_sc_hd__fill_1
XFILLER_8_105 VPWR VGND VPWR VGND sky130_ef_sc_hd__decap_12
XFILLER_12_156 VGND VGND VPWR VPWR sky130_fd_sc_hd__decap_3
XFILLER_43_292 VPWR VGND VPWR VGND sky130_ef_sc_hd__decap_12
XFILLER_43_281 VGND VGND VPWR VPWR sky130_fd_sc_hd__decap_6
X_1723_ net75 _0804_ _0805_ VGND VGND VPWR VPWR _0806_ sky130_fd_sc_hd__nor3_1
X_1654_ _0705_ _0711_ _0739_ VGND VGND VPWR VPWR _0740_ sky130_fd_sc_hd__a21o_1
XTAP_TAPCELL_ROW_13_184 VGND VPWR sky130_fd_sc_hd__tapvpwrvgnd_1
X_1585_ _0671_ _0670_ _0672_ VGND VGND VPWR VPWR _0673_ sky130_fd_sc_hd__and3_1
X_1019_ _0034_ _0045_ net78 VGND VGND VPWR VPWR _0056_ sky130_fd_sc_hd__a21o_1
XFILLER_34_281 VGND VGND VPWR VPWR sky130_fd_sc_hd__decap_8
XFILLER_40_251 VGND VGND VPWR VPWR sky130_fd_sc_hd__fill_1
XFILLER_32_218 VGND VGND VPWR VPWR sky130_fd_sc_hd__fill_2
XFILLER_17_259 VPWR VGND VPWR VGND sky130_ef_sc_hd__decap_12
XFILLER_25_281 VGND VGND VPWR VPWR sky130_fd_sc_hd__decap_6
XFILLER_40_273 VPWR VGND VPWR VGND sky130_ef_sc_hd__decap_12
XTAP_TAPCELL_ROW_10_165 VGND VPWR sky130_fd_sc_hd__tapvpwrvgnd_1
XFILLER_4_163 VGND VGND VPWR VPWR sky130_fd_sc_hd__decap_6
X_1370_ _0415_ _0420_ VGND VGND VPWR VPWR _0464_ sky130_fd_sc_hd__nor2_1
XTAP_TAPCELL_ROW_18_210 VGND VPWR sky130_fd_sc_hd__tapvpwrvgnd_1
X_1637_ _0719_ _0721_ net66 VGND VGND VPWR VPWR _0723_ sky130_fd_sc_hd__a21o_1
X_1706_ _0787_ _0788_ net60 VGND VGND VPWR VPWR _0790_ sky130_fd_sc_hd__o21ai_1
XFILLER_48_29 VPWR VGND VPWR VGND sky130_ef_sc_hd__decap_12
X_1568_ _0652_ _0653_ net73 VGND VGND VPWR VPWR _0656_ sky130_fd_sc_hd__o21ai_1
X_1499_ _0552_ _0553_ VGND VGND VPWR VPWR _0589_ sky130_fd_sc_hd__or2_4
XFILLER_22_251 VGND VGND VPWR VPWR sky130_fd_sc_hd__fill_1
XTAP_TAPCELL_ROW_24_246 VGND VPWR sky130_fd_sc_hd__tapvpwrvgnd_1
Xfanout66 net67 VGND VGND VPWR VPWR net66 sky130_fd_sc_hd__clkbuf_4
Xfanout88 _0879_ VGND VGND VPWR VPWR net88 sky130_fd_sc_hd__clkbuf_4
XTAP_TAPCELL_ROW_32_290 VGND VPWR sky130_fd_sc_hd__tapvpwrvgnd_1
Xfanout77 _0306_ VGND VGND VPWR VPWR net77 sky130_fd_sc_hd__buf_8
Xfanout99 net5 VGND VGND VPWR VPWR net99 sky130_fd_sc_hd__clkbuf_2
XFILLER_13_21 VGND VGND VPWR VPWR sky130_fd_sc_hd__fill_2
XFILLER_13_54 VGND VGND VPWR VPWR sky130_fd_sc_hd__fill_2
XFILLER_1_111 VGND VGND VPWR VPWR sky130_fd_sc_hd__fill_1
XFILLER_1_144 VGND VGND VPWR VPWR sky130_fd_sc_hd__fill_1
XFILLER_1_166 VGND VGND VPWR VPWR sky130_fd_sc_hd__fill_2
XFILLER_8_3 VPWR VGND VPWR VGND sky130_ef_sc_hd__decap_12
XFILLER_49_159 VGND VGND VPWR VPWR sky130_fd_sc_hd__fill_1
XFILLER_9_211 VGND VGND VPWR VPWR sky130_fd_sc_hd__fill_1
XFILLER_9_277 VGND VGND VPWR VPWR sky130_fd_sc_hd__decap_3
XFILLER_13_273 VGND VGND VPWR VPWR sky130_fd_sc_hd__decap_6
X_1422_ net96 _0471_ _0472_ _0474_ VGND VGND VPWR VPWR _0514_ sky130_fd_sc_hd__a22o_1
X_1284_ net5 net98 net109 net106 VGND VGND VPWR VPWR _0379_ sky130_fd_sc_hd__and4_1
X_1353_ _0391_ _0398_ _0397_ VGND VGND VPWR VPWR _0447_ sky130_fd_sc_hd__a21bo_1
XTAP_TAPCELL_ROW_21_227 VGND VPWR sky130_fd_sc_hd__tapvpwrvgnd_1
XFILLER_24_42 VGND VGND VPWR VPWR sky130_fd_sc_hd__decap_3
XFILLER_40_41 VGND VGND VPWR VPWR sky130_fd_sc_hd__decap_3
XFILLER_10_265 VPWR VGND VPWR VGND sky130_ef_sc_hd__decap_12
XFILLER_37_107 VGND VGND VPWR VPWR sky130_fd_sc_hd__fill_1
X_1971_ _0058_ _0060_ _0089_ VGND VGND VPWR VPWR _0091_ sky130_fd_sc_hd__o21ai_1
X_1405_ _0497_ VGND VGND VPWR VPWR _0498_ sky130_fd_sc_hd__inv_2
XFILLER_28_118 VPWR VGND VPWR VGND sky130_ef_sc_hd__decap_12
XFILLER_28_107 VGND VGND VPWR VPWR sky130_fd_sc_hd__fill_1
Xinput1 activation[0] VGND VGND VPWR VPWR net1 sky130_fd_sc_hd__clkbuf_1
X_1198_ net104 _0868_ VGND VGND VPWR VPWR _0295_ sky130_fd_sc_hd__nor2_1
X_1267_ _0345_ _0362_ _0361_ VGND VGND VPWR VPWR _0363_ sky130_fd_sc_hd__and3_1
X_1336_ _0424_ _0429_ VGND VGND VPWR VPWR _0430_ sky130_fd_sc_hd__nand2_1
XFILLER_51_187 VGND VGND VPWR VPWR sky130_fd_sc_hd__decap_4
XFILLER_51_154 VGND VGND VPWR VPWR sky130_fd_sc_hd__decap_4
XFILLER_51_132 VGND VGND VPWR VPWR sky130_fd_sc_hd__decap_4
XFILLER_51_121 VGND VGND VPWR VPWR sky130_fd_sc_hd__decap_3
XFILLER_36_195 VGND VGND VPWR VPWR sky130_fd_sc_hd__fill_1
XFILLER_3_217 VGND VGND VPWR VPWR sky130_fd_sc_hd__decap_6
XPHY_EDGE_ROW_40_Left_92 VGND VGND VPWR VPWR sky130_fd_sc_hd__decap_3
XFILLER_27_195 VGND VGND VPWR VPWR sky130_fd_sc_hd__decap_3
XFILLER_42_165 VGND VGND VPWR VPWR sky130_fd_sc_hd__decap_4
XTAP_TAPCELL_ROW_40_333 VGND VPWR sky130_fd_sc_hd__tapvpwrvgnd_1
X_1121_ net102 net110 VGND VGND VPWR VPWR _0220_ sky130_fd_sc_hd__nand2_1
X_1052_ _0130_ _0132_ _0153_ VGND VGND VPWR VPWR _0154_ sky130_fd_sc_hd__a21o_1
X_1954_ _0588_ _0071_ VGND VGND VPWR VPWR _0073_ sky130_fd_sc_hd__xnor2_1
X_1885_ net148 _0935_ _0934_ VGND VGND VPWR VPWR _0970_ sky130_fd_sc_hd__o21ai_1
XFILLER_0_209 VGND VGND VPWR VPWR sky130_fd_sc_hd__decap_4
X_1319_ _0412_ _0413_ VGND VGND VPWR VPWR _0414_ sky130_fd_sc_hd__xnor2_1
XFILLER_24_187 VGND VGND VPWR VPWR sky130_fd_sc_hd__fill_2
XFILLER_47_213 VGND VGND VPWR VPWR sky130_fd_sc_hd__decap_3
XFILLER_15_132 VGND VGND VPWR VPWR sky130_fd_sc_hd__decap_8
XFILLER_15_187 VGND VGND VPWR VPWR sky130_fd_sc_hd__decap_4
X_1670_ _0751_ _0752_ _0753_ VGND VGND VPWR VPWR _0755_ sky130_fd_sc_hd__and3_1
XFILLER_7_89 VGND VGND VPWR VPWR sky130_fd_sc_hd__decap_3
XFILLER_7_34 VPWR VGND VPWR VGND sky130_ef_sc_hd__decap_12
XFILLER_23_3 VGND VGND VPWR VPWR sky130_fd_sc_hd__fill_2
X_1104_ _0202_ _0203_ VGND VGND VPWR VPWR _0204_ sky130_fd_sc_hd__nor2_1
X_1035_ net199 net82 _0137_ net86 VGND VGND VPWR VPWR _0004_ sky130_fd_sc_hd__o211a_1
X_1937_ net40 net84 VGND VGND VPWR VPWR _0057_ sky130_fd_sc_hd__or2_1
X_1799_ _0844_ _0845_ VGND VGND VPWR VPWR _0882_ sky130_fd_sc_hd__nand2_1
X_1868_ _0871_ _0952_ VGND VGND VPWR VPWR _0953_ sky130_fd_sc_hd__nor2_1
XFILLER_29_268 VGND VGND VPWR VPWR sky130_fd_sc_hd__decap_8
XFILLER_32_53 VGND VGND VPWR VPWR sky130_fd_sc_hd__fill_2
XFILLER_4_301 VGND VGND VPWR VPWR sky130_fd_sc_hd__decap_6
XFILLER_8_117 VPWR VGND VPWR VGND sky130_ef_sc_hd__decap_12
XTAP_TAPCELL_ROW_7_150 VGND VPWR sky130_fd_sc_hd__tapvpwrvgnd_1
XFILLER_43_271 VGND VGND VPWR VPWR sky130_fd_sc_hd__decap_8
X_1722_ net122 net94 net34 VGND VGND VPWR VPWR _0805_ sky130_fd_sc_hd__a21oi_1
X_1653_ _0702_ _0737_ VGND VGND VPWR VPWR _0739_ sky130_fd_sc_hd__xnor2_2
X_1584_ net56 _0641_ _0640_ VGND VGND VPWR VPWR _0672_ sky130_fd_sc_hd__o21bai_1
XPHY_EDGE_ROW_9_Right_9 VGND VGND VPWR VPWR sky130_fd_sc_hd__decap_3
XTAP_TAPCELL_ROW_13_185 VGND VPWR sky130_fd_sc_hd__tapvpwrvgnd_1
XFILLER_34_293 VPWR VGND VPWR VGND sky130_ef_sc_hd__decap_12
X_1018_ _0941_ _0983_ _0993_ VGND VGND VPWR VPWR _0045_ sky130_fd_sc_hd__or3_1
XFILLER_5_109 VGND VGND VPWR VPWR sky130_fd_sc_hd__decap_3
XTAP_TAPCELL_ROW_4_131 VGND VPWR sky130_fd_sc_hd__tapvpwrvgnd_1
XFILLER_40_296 VPWR VGND VPWR VGND sky130_ef_sc_hd__decap_12
XFILLER_40_285 VGND VGND VPWR VPWR sky130_fd_sc_hd__decap_4
XFILLER_27_97 VGND VGND VPWR VPWR sky130_fd_sc_hd__decap_6
XTAP_TAPCELL_ROW_10_166 VGND VPWR sky130_fd_sc_hd__tapvpwrvgnd_1
XTAP_TAPCELL_ROW_18_211 VGND VPWR sky130_fd_sc_hd__tapvpwrvgnd_1
X_1705_ net58 _0787_ _0788_ VGND VGND VPWR VPWR _0789_ sky130_fd_sc_hd__or3_1
XFILLER_31_285 VGND VGND VPWR VPWR sky130_fd_sc_hd__fill_1
XFILLER_31_252 VGND VGND VPWR VPWR sky130_fd_sc_hd__fill_1
X_1636_ _0720_ net64 _0719_ VGND VGND VPWR VPWR _0722_ sky130_fd_sc_hd__or3b_1
X_1567_ net73 _0652_ _0653_ VGND VGND VPWR VPWR _0655_ sky130_fd_sc_hd__or3_4
XTAP_TAPCELL_ROW_49_380 VGND VPWR sky130_fd_sc_hd__tapvpwrvgnd_1
X_1498_ _0552_ _0553_ VGND VGND VPWR VPWR _0588_ sky130_fd_sc_hd__nor2_4
Xfanout89 _0879_ VGND VGND VPWR VPWR net89 sky130_fd_sc_hd__buf_2
Xfanout56 _0586_ VGND VGND VPWR VPWR net56 sky130_fd_sc_hd__buf_4
Xfanout67 _0435_ VGND VGND VPWR VPWR net67 sky130_fd_sc_hd__buf_4
Xfanout78 net81 VGND VGND VPWR VPWR net78 sky130_fd_sc_hd__clkbuf_4
X_1421_ _0505_ _0510_ VGND VGND VPWR VPWR _0513_ sky130_fd_sc_hd__nand2_1
XFILLER_48_182 VGND VGND VPWR VPWR sky130_fd_sc_hd__fill_1
X_1283_ net96 _0346_ _0348_ _0349_ VGND VGND VPWR VPWR _0378_ sky130_fd_sc_hd__o2bb2a_1
X_1352_ _0443_ _0444_ net68 VGND VGND VPWR VPWR _0446_ sky130_fd_sc_hd__a21o_1
XTAP_TAPCELL_ROW_21_228 VGND VPWR sky130_fd_sc_hd__tapvpwrvgnd_1
X_1619_ _0702_ _0704_ _0673_ VGND VGND VPWR VPWR _0706_ sky130_fd_sc_hd__o21bai_1
XFILLER_10_277 VPWR VGND VPWR VGND sky130_ef_sc_hd__decap_12
XFILLER_40_75 VGND VGND VPWR VPWR sky130_fd_sc_hd__fill_2
XFILLER_40_64 VGND VGND VPWR VPWR sky130_fd_sc_hd__fill_2
XFILLER_49_51 VGND VGND VPWR VPWR sky130_fd_sc_hd__decap_4
XFILLER_1_47 VGND VGND VPWR VPWR sky130_fd_sc_hd__fill_2
X_1970_ _0058_ _0060_ _0089_ VGND VGND VPWR VPWR _0090_ sky130_fd_sc_hd__or3_1
XFILLER_5_281 VPWR VGND VPWR VGND sky130_ef_sc_hd__decap_12
X_1335_ _0427_ _0428_ VGND VGND VPWR VPWR _0429_ sky130_fd_sc_hd__xnor2_1
X_1404_ _0448_ _0451_ _0495_ _0496_ VGND VGND VPWR VPWR _0497_ sky130_fd_sc_hd__o211a_1
X_1197_ _0292_ _0293_ VGND VGND VPWR VPWR _0294_ sky130_fd_sc_hd__nor2_1
X_1266_ _0359_ _0358_ _0360_ VGND VGND VPWR VPWR _0362_ sky130_fd_sc_hd__a21o_1
Xinput2 activation[1] VGND VGND VPWR VPWR net2 sky130_fd_sc_hd__clkbuf_1
XFILLER_19_87 VGND VGND VPWR VPWR sky130_fd_sc_hd__fill_2
XFILLER_42_177 VGND VGND VPWR VPWR sky130_fd_sc_hd__decap_8
XFILLER_51_96 VGND VGND VPWR VPWR sky130_fd_sc_hd__decap_4
XFILLER_51_85 VGND VGND VPWR VPWR sky130_fd_sc_hd__decap_6
XFILLER_51_41 VGND VGND VPWR VPWR sky130_fd_sc_hd__decap_8
XTAP_TAPCELL_ROW_40_334 VGND VPWR sky130_fd_sc_hd__tapvpwrvgnd_1
XFILLER_2_251 VGND VGND VPWR VPWR sky130_fd_sc_hd__fill_1
XFILLER_33_111 VGND VGND VPWR VPWR sky130_fd_sc_hd__fill_1
X_1120_ _0213_ _0217_ VGND VGND VPWR VPWR _0219_ sky130_fd_sc_hd__xnor2_1
X_1051_ _0151_ _0152_ VGND VGND VPWR VPWR _0153_ sky130_fd_sc_hd__nand2_1
XFILLER_33_188 VGND VGND VPWR VPWR sky130_fd_sc_hd__fill_1
X_1884_ net68 _0967_ VGND VGND VPWR VPWR _0969_ sky130_fd_sc_hd__xnor2_1
XFILLER_21_306 VGND VGND VPWR VPWR sky130_fd_sc_hd__decap_3
X_1953_ net59 _0071_ VGND VGND VPWR VPWR _0072_ sky130_fd_sc_hd__nor2_1
X_1318_ _0366_ _0368_ VGND VGND VPWR VPWR _0413_ sky130_fd_sc_hd__and2b_1
X_1249_ _0335_ _0343_ VGND VGND VPWR VPWR _0345_ sky130_fd_sc_hd__xnor2_1
XFILLER_47_225 VGND VGND VPWR VPWR sky130_fd_sc_hd__fill_2
XFILLER_46_85 VGND VGND VPWR VPWR sky130_fd_sc_hd__decap_4
XFILLER_46_41 VPWR VGND VPWR VGND sky130_ef_sc_hd__decap_12
XFILLER_30_147 VGND VGND VPWR VPWR sky130_fd_sc_hd__fill_2
XFILLER_15_166 VGND VGND VPWR VPWR sky130_fd_sc_hd__fill_2
XFILLER_7_57 VGND VGND VPWR VPWR sky130_fd_sc_hd__decap_4
XFILLER_7_46 VGND VGND VPWR VPWR sky130_fd_sc_hd__decap_8
X_1103_ net124 net108 _0160_ _0162_ VGND VGND VPWR VPWR _0203_ sky130_fd_sc_hd__a211oi_1
X_1034_ _0135_ _0136_ net82 VGND VGND VPWR VPWR _0137_ sky130_fd_sc_hd__o21ai_1
X_1867_ _0898_ _0925_ VGND VGND VPWR VPWR _0952_ sky130_fd_sc_hd__nand2_1
X_1936_ _0047_ _0053_ VGND VGND VPWR VPWR _0055_ sky130_fd_sc_hd__xnor2_1
X_1798_ net142 _0880_ VGND VGND VPWR VPWR _0881_ sky130_fd_sc_hd__xnor2_1
XFILLER_44_206 VPWR VGND VPWR VGND sky130_ef_sc_hd__decap_12
XFILLER_29_225 VGND VGND VPWR VPWR sky130_fd_sc_hd__decap_3
XFILLER_8_129 VGND VGND VPWR VPWR sky130_fd_sc_hd__decap_8
XFILLER_20_180 VPWR VGND VPWR VGND sky130_ef_sc_hd__decap_12
XTAP_TAPCELL_ROW_7_151 VGND VPWR sky130_fd_sc_hd__tapvpwrvgnd_1
X_1721_ net34 net122 net94 VGND VGND VPWR VPWR _0804_ sky130_fd_sc_hd__and3_1
XFILLER_11_191 VPWR VGND VPWR VGND sky130_ef_sc_hd__decap_12
X_1652_ _0703_ _0737_ VGND VGND VPWR VPWR _0738_ sky130_fd_sc_hd__nor2_1
X_1583_ _0668_ _0669_ net61 VGND VGND VPWR VPWR _0671_ sky130_fd_sc_hd__a21o_1
XFILLER_7_162 VGND VGND VPWR VPWR sky130_fd_sc_hd__decap_6
XFILLER_7_173 VGND VGND VPWR VPWR sky130_fd_sc_hd__fill_1
XFILLER_41_209 VGND VGND VPWR VPWR sky130_fd_sc_hd__fill_1
X_1017_ _0983_ _0993_ _0941_ VGND VGND VPWR VPWR _0034_ sky130_fd_sc_hd__o21ai_1
X_1919_ _0036_ _0035_ VGND VGND VPWR VPWR _0037_ sky130_fd_sc_hd__and2b_1
XTAP_TAPCELL_ROW_4_132 VGND VPWR sky130_fd_sc_hd__tapvpwrvgnd_1
XFILLER_1_305 VGND VGND VPWR VPWR sky130_fd_sc_hd__decap_4
XFILLER_27_65 VGND VGND VPWR VPWR sky130_fd_sc_hd__fill_1
XFILLER_43_20 VGND VGND VPWR VPWR sky130_fd_sc_hd__decap_4
XFILLER_40_264 VGND VGND VPWR VPWR sky130_fd_sc_hd__fill_2
Xclone52 net178 VGND VGND VPWR VPWR net177 sky130_fd_sc_hd__clkbuf_1
XTAP_TAPCELL_ROW_10_167 VGND VPWR sky130_fd_sc_hd__tapvpwrvgnd_1
XTAP_TAPCELL_ROW_18_212 VGND VPWR sky130_fd_sc_hd__tapvpwrvgnd_1
X_1704_ _0784_ _0785_ _0786_ VGND VGND VPWR VPWR _0788_ sky130_fd_sc_hd__and3_1
X_1635_ _0681_ _0683_ _0717_ _0718_ VGND VGND VPWR VPWR _0721_ sky130_fd_sc_hd__o211ai_1
X_1566_ net73 _0652_ _0653_ VGND VGND VPWR VPWR _0654_ sky130_fd_sc_hd__nor3_1
X_1497_ _0554_ net62 VGND VGND VPWR VPWR _0587_ sky130_fd_sc_hd__or2_1
XTAP_TAPCELL_ROW_49_381 VGND VPWR sky130_fd_sc_hd__tapvpwrvgnd_1
Xfanout57 net58 VGND VGND VPWR VPWR net57 sky130_fd_sc_hd__buf_6
Xfanout79 net81 VGND VGND VPWR VPWR net79 sky130_fd_sc_hd__buf_2
Xfanout68 _0435_ VGND VGND VPWR VPWR net68 sky130_fd_sc_hd__clkbuf_4
X_1420_ net79 _0511_ _0512_ net88 VGND VGND VPWR VPWR _0014_ sky130_fd_sc_hd__o211a_1
X_1351_ net65 _0442_ _0444_ VGND VGND VPWR VPWR _0445_ sky130_fd_sc_hd__or3b_4
XFILLER_48_172 VGND VGND VPWR VPWR sky130_fd_sc_hd__fill_1
XTAP_TAPCELL_ROW_38_318 VGND VPWR sky130_fd_sc_hd__tapvpwrvgnd_1
X_1282_ _0339_ _0340_ _0337_ VGND VGND VPWR VPWR _0377_ sky130_fd_sc_hd__a21oi_1
XTAP_TAPCELL_ROW_46_362 VGND VPWR sky130_fd_sc_hd__tapvpwrvgnd_1
XTAP_TAPCELL_ROW_21_229 VGND VPWR sky130_fd_sc_hd__tapvpwrvgnd_1
X_1618_ _0704_ _0702_ _0673_ VGND VGND VPWR VPWR _0705_ sky130_fd_sc_hd__or3b_4
X_1549_ _0635_ _0636_ net58 VGND VGND VPWR VPWR _0638_ sky130_fd_sc_hd__o21ai_1
XFILLER_24_11 VGND VGND VPWR VPWR sky130_fd_sc_hd__decap_4
XFILLER_6_249 VGND VGND VPWR VPWR sky130_fd_sc_hd__decap_3
XFILLER_10_289 VPWR VGND VPWR VGND sky130_ef_sc_hd__decap_12
XFILLER_45_153 VGND VGND VPWR VPWR sky130_fd_sc_hd__fill_2
XFILLER_1_15 VPWR VGND VPWR VGND sky130_ef_sc_hd__decap_12
XFILLER_45_175 VGND VGND VPWR VPWR sky130_fd_sc_hd__fill_1
XFILLER_46_3 VPWR VGND VPWR VGND sky130_ef_sc_hd__decap_12
XFILLER_5_293 VPWR VGND VPWR VGND sky130_ef_sc_hd__decap_12
X_1265_ _0358_ _0359_ _0360_ VGND VGND VPWR VPWR _0361_ sky130_fd_sc_hd__nand3_2
XPHY_EDGE_ROW_18_Right_18 VGND VGND VPWR VPWR sky130_fd_sc_hd__decap_3
X_1334_ net5 _0868_ VGND VGND VPWR VPWR _0428_ sky130_fd_sc_hd__nor2_1
X_1403_ _0479_ _0493_ VGND VGND VPWR VPWR _0496_ sky130_fd_sc_hd__or2_1
XFILLER_36_197 VGND VGND VPWR VPWR sky130_fd_sc_hd__decap_6
XPHY_EDGE_ROW_27_Right_27 VGND VGND VPWR VPWR sky130_fd_sc_hd__decap_3
X_1196_ net100 net108 net106 net102 VGND VGND VPWR VPWR _0293_ sky130_fd_sc_hd__a22oi_1
Xinput3 activation[2] VGND VGND VPWR VPWR net3 sky130_fd_sc_hd__buf_1
XPHY_EDGE_ROW_36_Right_36 VGND VGND VPWR VPWR sky130_fd_sc_hd__decap_3
XFILLER_10_68 VPWR VGND VPWR VGND sky130_ef_sc_hd__decap_12
XFILLER_19_22 VGND VGND VPWR VPWR sky130_fd_sc_hd__fill_2
XFILLER_19_55 VGND VGND VPWR VPWR sky130_fd_sc_hd__fill_1
XPHY_EDGE_ROW_45_Right_45 VGND VGND VPWR VPWR sky130_fd_sc_hd__decap_3
XPHY_EDGE_ROW_27_Left_79 VGND VGND VPWR VPWR sky130_fd_sc_hd__decap_3
X_1050_ _0145_ _0150_ VGND VGND VPWR VPWR _0152_ sky130_fd_sc_hd__or2_1
XFILLER_18_7 VGND VGND VPWR VPWR sky130_fd_sc_hd__fill_2
XFILLER_18_131 VGND VGND VPWR VPWR sky130_fd_sc_hd__decap_8
XFILLER_18_197 VGND VGND VPWR VPWR sky130_fd_sc_hd__fill_1
X_1883_ net140 _0967_ VGND VGND VPWR VPWR _0968_ sky130_fd_sc_hd__nor2_1
X_1952_ _0069_ _0070_ VGND VGND VPWR VPWR _0071_ sky130_fd_sc_hd__or2_1
X_1248_ _0335_ _0343_ VGND VGND VPWR VPWR _0344_ sky130_fd_sc_hd__nand2b_1
X_1317_ _0410_ _0411_ VGND VGND VPWR VPWR _0412_ sky130_fd_sc_hd__nand2_1
X_1179_ _0276_ _0275_ VGND VGND VPWR VPWR _0277_ sky130_fd_sc_hd__and2b_1
XFILLER_21_34 VGND VGND VPWR VPWR sky130_fd_sc_hd__decap_6
XFILLER_46_53 VGND VGND VPWR VPWR sky130_fd_sc_hd__decap_3
XFILLER_7_25 VGND VGND VPWR VPWR sky130_fd_sc_hd__fill_2
XFILLER_7_69 VPWR VGND VPWR VGND sky130_ef_sc_hd__decap_12
X_1102_ _0160_ _0162_ net124 net108 VGND VGND VPWR VPWR _0202_ sky130_fd_sc_hd__o211a_1
X_1033_ _0045_ _0134_ VGND VGND VPWR VPWR _0136_ sky130_fd_sc_hd__and2_1
X_1797_ _0877_ _0878_ VGND VGND VPWR VPWR _0880_ sky130_fd_sc_hd__nor2_1
X_1866_ _0922_ _0949_ VGND VGND VPWR VPWR _0951_ sky130_fd_sc_hd__xor2_1
X_1935_ _0053_ _0048_ VGND VGND VPWR VPWR _0054_ sky130_fd_sc_hd__or2_4
XFILLER_44_218 VPWR VGND VPWR VGND sky130_ef_sc_hd__decap_12
XPHY_EDGE_ROW_0_Right_0 VGND VGND VPWR VPWR sky130_fd_sc_hd__decap_3
XTAP_TAPCELL_ROW_7_152 VGND VPWR sky130_fd_sc_hd__tapvpwrvgnd_1
XFILLER_35_229 VPWR VGND VPWR VGND sky130_ef_sc_hd__decap_12
X_1720_ net205 net83 _0802_ _0803_ net87 VGND VGND VPWR VPWR _0023_ sky130_fd_sc_hd__o221a_1
X_1651_ _0736_ _0735_ VGND VGND VPWR VPWR _0737_ sky130_fd_sc_hd__or2_4
XFILLER_11_181 VGND VGND VPWR VPWR sky130_fd_sc_hd__decap_3
X_1582_ net61 _0668_ _0669_ VGND VGND VPWR VPWR _0670_ sky130_fd_sc_hd__nand3_1
XFILLER_19_281 VPWR VGND VPWR VGND sky130_ef_sc_hd__decap_12
XFILLER_34_273 VGND VGND VPWR VPWR sky130_fd_sc_hd__decap_4
XFILLER_34_251 VGND VGND VPWR VPWR sky130_fd_sc_hd__fill_1
XPHY_EDGE_ROW_14_Left_66 VGND VGND VPWR VPWR sky130_fd_sc_hd__decap_3
X_1016_ net115 net125 _0961_ _0972_ VGND VGND VPWR VPWR _0993_ sky130_fd_sc_hd__o2bb2a_1
X_1849_ _0903_ _0905_ VGND VGND VPWR VPWR _0933_ sky130_fd_sc_hd__nand2b_1
X_1918_ _0969_ _0970_ _0973_ VGND VGND VPWR VPWR _0036_ sky130_fd_sc_hd__a21oi_1
XTAP_TAPCELL_ROW_4_133 VGND VPWR sky130_fd_sc_hd__tapvpwrvgnd_1
XFILLER_27_55 VGND VGND VPWR VPWR sky130_fd_sc_hd__fill_1
XFILLER_43_76 VGND VGND VPWR VPWR sky130_fd_sc_hd__decap_3
Xclone53 _0306_ VGND VGND VPWR VPWR net178 sky130_fd_sc_hd__clkbuf_1
XFILLER_4_133 VGND VGND VPWR VPWR sky130_fd_sc_hd__decap_6
XFILLER_4_122 VGND VGND VPWR VPWR sky130_fd_sc_hd__fill_1
XTAP_TAPCELL_ROW_10_168 VGND VPWR sky130_fd_sc_hd__tapvpwrvgnd_1
XTAP_TAPCELL_ROW_18_213 VGND VPWR sky130_fd_sc_hd__tapvpwrvgnd_1
XFILLER_16_295 VGND VGND VPWR VPWR sky130_fd_sc_hd__decap_8
X_1634_ _0681_ _0683_ _0717_ _0718_ VGND VGND VPWR VPWR _0720_ sky130_fd_sc_hd__o211a_1
X_1703_ _0784_ _0785_ _0786_ VGND VGND VPWR VPWR _0787_ sky130_fd_sc_hd__a21oi_1
X_1565_ net120 net93 net28 VGND VGND VPWR VPWR _0653_ sky130_fd_sc_hd__a21oi_1
X_1496_ net63 VGND VGND VPWR VPWR _0586_ sky130_fd_sc_hd__inv_2
XTAP_TAPCELL_ROW_49_382 VGND VPWR sky130_fd_sc_hd__tapvpwrvgnd_1
Xfanout69 _0435_ VGND VGND VPWR VPWR net69 sky130_fd_sc_hd__clkbuf_2
Xfanout58 net60 VGND VGND VPWR VPWR net58 sky130_fd_sc_hd__buf_6
XFILLER_13_57 VGND VGND VPWR VPWR sky130_fd_sc_hd__decap_6
XFILLER_49_129 VGND VGND VPWR VPWR sky130_fd_sc_hd__fill_1
XFILLER_38_76 VGND VGND VPWR VPWR sky130_fd_sc_hd__fill_2
XFILLER_9_203 VGND VGND VPWR VPWR sky130_fd_sc_hd__decap_8
XFILLER_13_221 VGND VGND VPWR VPWR sky130_fd_sc_hd__decap_3
X_1281_ net51 net84 _0375_ _0376_ net88 VGND VGND VPWR VPWR _0011_ sky130_fd_sc_hd__o221a_1
X_1350_ _0440_ _0441_ _0392_ _0394_ VGND VGND VPWR VPWR _0444_ sky130_fd_sc_hd__a211o_1
XFILLER_51_305 VGND VGND VPWR VPWR sky130_fd_sc_hd__decap_3
XTAP_TAPCELL_ROW_46_363 VGND VPWR sky130_fd_sc_hd__tapvpwrvgnd_1
XTAP_TAPCELL_ROW_38_319 VGND VPWR sky130_fd_sc_hd__tapvpwrvgnd_1
X_1617_ _0699_ _0700_ _0701_ VGND VGND VPWR VPWR _0704_ sky130_fd_sc_hd__a21oi_1
XFILLER_39_184 VGND VGND VPWR VPWR sky130_fd_sc_hd__fill_1
X_1548_ net58 _0635_ _0636_ VGND VGND VPWR VPWR _0637_ sky130_fd_sc_hd__or3_4
X_1479_ _0567_ _0568_ _0555_ VGND VGND VPWR VPWR _0570_ sky130_fd_sc_hd__a21o_1
XFILLER_6_3 VGND VGND VPWR VPWR sky130_fd_sc_hd__decap_8
XFILLER_1_27 VPWR VGND VPWR VGND sky130_ef_sc_hd__decap_12
XFILLER_18_302 VGND VGND VPWR VPWR sky130_fd_sc_hd__decap_6
X_1402_ _0479_ _0493_ VGND VGND VPWR VPWR _0495_ sky130_fd_sc_hd__nand2_1
XFILLER_39_3 VGND VGND VPWR VPWR sky130_fd_sc_hd__fill_1
Xinput4 activation[3] VGND VGND VPWR VPWR net4 sky130_fd_sc_hd__clkbuf_1
X_1264_ _0305_ _0314_ _0313_ VGND VGND VPWR VPWR _0360_ sky130_fd_sc_hd__a21bo_1
X_1333_ _0425_ _0426_ VGND VGND VPWR VPWR _0427_ sky130_fd_sc_hd__nand2b_1
XFILLER_51_113 VGND VGND VPWR VPWR sky130_fd_sc_hd__decap_8
XTAP_TAPCELL_ROW_34_300 VGND VPWR sky130_fd_sc_hd__tapvpwrvgnd_1
Xclkbuf_2_1__f_clk clknet_0_clk VGND VGND VPWR VPWR clknet_2_1__leaf_clk sky130_fd_sc_hd__clkbuf_16
X_1195_ net102 net100 net108 net106 VGND VGND VPWR VPWR _0292_ sky130_fd_sc_hd__and4_1
XFILLER_27_110 VGND VGND VPWR VPWR sky130_fd_sc_hd__fill_2
XFILLER_50_190 VGND VGND VPWR VPWR sky130_fd_sc_hd__fill_2
XFILLER_42_157 VGND VGND VPWR VPWR sky130_fd_sc_hd__decap_4
XFILLER_27_187 VGND VGND VPWR VPWR sky130_fd_sc_hd__fill_2
XPHY_EDGE_ROW_2_Left_54 VGND VGND VPWR VPWR sky130_fd_sc_hd__decap_3
XFILLER_2_253 VPWR VGND VPWR VGND sky130_ef_sc_hd__decap_12
XFILLER_33_157 VGND VGND VPWR VPWR sky130_fd_sc_hd__decap_8
XFILLER_18_187 VGND VGND VPWR VPWR sky130_fd_sc_hd__fill_2
X_1882_ _0965_ _0966_ VGND VGND VPWR VPWR _0967_ sky130_fd_sc_hd__xnor2_1
X_1951_ _0995_ _0997_ _0068_ VGND VGND VPWR VPWR _0070_ sky130_fd_sc_hd__o21a_1
X_1178_ _0219_ _0237_ _0236_ VGND VGND VPWR VPWR _0276_ sky130_fd_sc_hd__a21boi_1
XFILLER_2_70 VGND VGND VPWR VPWR sky130_fd_sc_hd__fill_2
X_1247_ _0336_ _0341_ VGND VGND VPWR VPWR _0343_ sky130_fd_sc_hd__xnor2_1
X_1316_ _0407_ _0409_ _0342_ _0344_ VGND VGND VPWR VPWR _0411_ sky130_fd_sc_hd__o211ai_1
XPHY_EDGE_ROW_44_Left_96 VGND VGND VPWR VPWR sky130_fd_sc_hd__decap_3
XFILLER_32_190 VGND VGND VPWR VPWR sky130_fd_sc_hd__decap_3
XFILLER_21_79 VGND VGND VPWR VPWR sky130_fd_sc_hd__fill_2
Xmax_cap55 _0324_ VGND VGND VPWR VPWR net55 sky130_fd_sc_hd__clkbuf_2
XFILLER_7_15 VGND VGND VPWR VPWR sky130_fd_sc_hd__decap_3
XFILLER_38_227 VPWR VGND VPWR VGND sky130_ef_sc_hd__decap_12
X_1101_ _0198_ _0199_ _0185_ VGND VGND VPWR VPWR _0201_ sky130_fd_sc_hd__a21o_1
X_1032_ _0045_ _0134_ VGND VGND VPWR VPWR _0135_ sky130_fd_sc_hd__nor2_1
X_1934_ _0051_ _0952_ _0871_ _0052_ VGND VGND VPWR VPWR _0053_ sky130_fd_sc_hd__o31a_1
XFILLER_21_105 VGND VGND VPWR VPWR sky130_fd_sc_hd__fill_1
XFILLER_21_116 VGND VGND VPWR VPWR sky130_fd_sc_hd__decap_3
XFILLER_21_138 VGND VGND VPWR VPWR sky130_fd_sc_hd__decap_6
X_1796_ _0838_ _0840_ _0875_ _0876_ VGND VGND VPWR VPWR _0878_ sky130_fd_sc_hd__o211a_1
X_1865_ _0922_ _0949_ VGND VGND VPWR VPWR _0950_ sky130_fd_sc_hd__nand2_1
XFILLER_29_216 VGND VGND VPWR VPWR sky130_fd_sc_hd__decap_4
XFILLER_16_24 VGND VGND VPWR VPWR sky130_fd_sc_hd__fill_1
XFILLER_32_45 VGND VGND VPWR VPWR sky130_fd_sc_hd__decap_8
XFILLER_35_208 VPWR VGND VPWR VGND sky130_ef_sc_hd__decap_12
XFILLER_28_271 VPWR VGND VPWR VGND sky130_ef_sc_hd__decap_12
X_1650_ _0732_ _0733_ _0734_ VGND VGND VPWR VPWR _0736_ sky130_fd_sc_hd__a21oi_1
X_1581_ _0665_ _0666_ _0667_ VGND VGND VPWR VPWR _0669_ sky130_fd_sc_hd__nand3_1
XFILLER_7_142 VGND VGND VPWR VPWR sky130_fd_sc_hd__decap_3
X_1015_ _0961_ _0972_ net115 net124 VGND VGND VPWR VPWR _0983_ sky130_fd_sc_hd__and4bb_1
X_1917_ _0588_ _1002_ VGND VGND VPWR VPWR _0035_ sky130_fd_sc_hd__xnor2_1
X_1779_ _0825_ _0859_ VGND VGND VPWR VPWR _0861_ sky130_fd_sc_hd__nand2_1
X_1848_ net76 _0931_ VGND VGND VPWR VPWR _0932_ sky130_fd_sc_hd__xnor2_1
XTAP_TAPCELL_ROW_4_134 VGND VPWR sky130_fd_sc_hd__tapvpwrvgnd_1
XFILLER_27_12 VGND VGND VPWR VPWR sky130_fd_sc_hd__decap_8
XFILLER_43_55 VGND VGND VPWR VPWR sky130_fd_sc_hd__fill_1
XFILLER_40_244 VGND VGND VPWR VPWR sky130_fd_sc_hd__fill_2
XTAP_TAPCELL_ROW_27_258 VGND VPWR sky130_fd_sc_hd__tapvpwrvgnd_1
XFILLER_27_89 VGND VGND VPWR VPWR sky130_fd_sc_hd__fill_1
XTAP_TAPCELL_ROW_10_169 VGND VPWR sky130_fd_sc_hd__tapvpwrvgnd_1
XPHY_EDGE_ROW_31_Left_83 VGND VGND VPWR VPWR sky130_fd_sc_hd__decap_3
X_1633_ _0717_ _0718_ _0681_ _0683_ VGND VGND VPWR VPWR _0719_ sky130_fd_sc_hd__a211o_1
X_1702_ net67 _0748_ _0749_ VGND VGND VPWR VPWR _0786_ sky130_fd_sc_hd__a21o_1
X_1564_ net28 net120 net93 VGND VGND VPWR VPWR _0652_ sky130_fd_sc_hd__and3_1
XTAP_TAPCELL_ROW_1_115 VGND VPWR sky130_fd_sc_hd__tapvpwrvgnd_1
X_1495_ _0470_ _0550_ _0553_ VGND VGND VPWR VPWR _0585_ sky130_fd_sc_hd__o21bai_4
XTAP_TAPCELL_ROW_49_383 VGND VPWR sky130_fd_sc_hd__tapvpwrvgnd_1
Xfanout59 net60 VGND VGND VPWR VPWR net59 sky130_fd_sc_hd__buf_2
XFILLER_22_288 VGND VGND VPWR VPWR sky130_fd_sc_hd__fill_2
XFILLER_22_299 VGND VGND VPWR VPWR sky130_fd_sc_hd__decap_8
XFILLER_1_126 VGND VGND VPWR VPWR sky130_fd_sc_hd__fill_1
XFILLER_48_141 VGND VGND VPWR VPWR sky130_fd_sc_hd__fill_2
X_1280_ _0373_ _0374_ net79 VGND VGND VPWR VPWR _0376_ sky130_fd_sc_hd__a21o_1
XFILLER_0_181 VPWR VGND VPWR VGND sky130_ef_sc_hd__decap_12
XTAP_TAPCELL_ROW_46_364 VGND VPWR sky130_fd_sc_hd__tapvpwrvgnd_1
XFILLER_36_303 VGND VGND VPWR VPWR sky130_fd_sc_hd__fill_1
X_1616_ _0702_ VGND VGND VPWR VPWR _0703_ sky130_fd_sc_hd__inv_2
X_1547_ _0633_ _0632_ _0634_ VGND VGND VPWR VPWR _0636_ sky130_fd_sc_hd__and3_1
X_1478_ _0555_ _0567_ _0568_ VGND VGND VPWR VPWR _0569_ sky130_fd_sc_hd__nand3_1
XFILLER_10_203 VGND VGND VPWR VPWR sky130_fd_sc_hd__decap_3
XFILLER_10_214 VPWR VGND VPWR VGND sky130_ef_sc_hd__decap_12
XTAP_TAPCELL_ROW_20_220 VGND VPWR sky130_fd_sc_hd__tapvpwrvgnd_1
XFILLER_1_39 VGND VGND VPWR VPWR sky130_fd_sc_hd__decap_8
X_1401_ _0491_ _0492_ _0479_ VGND VGND VPWR VPWR _0494_ sky130_fd_sc_hd__and3b_1
XFILLER_36_111 VGND VGND VPWR VPWR sky130_fd_sc_hd__decap_4
Xinput5 activation[4] VGND VGND VPWR VPWR net5 sky130_fd_sc_hd__dlymetal6s2s_1
X_1194_ _0221_ _0259_ _0258_ VGND VGND VPWR VPWR _0291_ sky130_fd_sc_hd__o21ba_1
X_1263_ _0357_ _0356_ _0350_ VGND VGND VPWR VPWR _0359_ sky130_fd_sc_hd__a21o_1
X_1332_ net96 net109 net107 net6 VGND VGND VPWR VPWR _0426_ sky130_fd_sc_hd__a22o_1
XFILLER_51_169 VGND VGND VPWR VPWR sky130_fd_sc_hd__fill_2
XFILLER_36_166 VPWR VGND VPWR VGND sky130_ef_sc_hd__decap_12
XTAP_TAPCELL_ROW_34_301 VGND VPWR sky130_fd_sc_hd__tapvpwrvgnd_1
XFILLER_42_125 VPWR VGND VPWR VGND sky130_ef_sc_hd__decap_12
XFILLER_35_34 VGND VGND VPWR VPWR sky130_fd_sc_hd__fill_1
XFILLER_19_57 VGND VGND VPWR VPWR sky130_fd_sc_hd__fill_1
XFILLER_2_265 VPWR VGND VPWR VGND sky130_ef_sc_hd__decap_12
XFILLER_2_221 VPWR VGND VPWR VGND sky130_ef_sc_hd__decap_12
XFILLER_33_125 VGND VGND VPWR VPWR sky130_fd_sc_hd__decap_4
X_1950_ _0995_ _0997_ _0068_ VGND VGND VPWR VPWR _0069_ sky130_fd_sc_hd__nor3_1
X_1881_ net115 net158 _0931_ _0928_ VGND VGND VPWR VPWR _0966_ sky130_fd_sc_hd__a31o_1
XFILLER_51_3 VPWR VGND VPWR VGND sky130_ef_sc_hd__decap_12
X_1315_ _0342_ _0344_ _0407_ _0409_ VGND VGND VPWR VPWR _0410_ sky130_fd_sc_hd__a211o_1
X_1177_ _0257_ _0273_ VGND VGND VPWR VPWR _0275_ sky130_fd_sc_hd__xor2_1
X_1246_ _0336_ _0341_ VGND VGND VPWR VPWR _0342_ sky130_fd_sc_hd__nand2b_1
XFILLER_24_158 VGND VGND VPWR VPWR sky130_fd_sc_hd__decap_3
XFILLER_46_99 VPWR VGND VPWR VGND sky130_ef_sc_hd__decap_12
XFILLER_30_128 VPWR VGND VPWR VGND sky130_ef_sc_hd__decap_12
XFILLER_15_169 VGND VGND VPWR VPWR sky130_fd_sc_hd__decap_8
XFILLER_38_239 VPWR VGND VPWR VGND sky130_ef_sc_hd__decap_12
X_1100_ _0185_ _0198_ _0199_ VGND VGND VPWR VPWR _0200_ sky130_fd_sc_hd__nand3_2
X_1031_ _0132_ _0133_ VGND VGND VPWR VPWR _0134_ sky130_fd_sc_hd__nand2_1
X_1933_ _0955_ _0050_ _0049_ _0984_ VGND VGND VPWR VPWR _0052_ sky130_fd_sc_hd__a211oi_1
XTAP_TAPCELL_ROW_16_197 VGND VPWR sky130_fd_sc_hd__tapvpwrvgnd_1
X_1795_ _0875_ _0876_ _0838_ _0840_ VGND VGND VPWR VPWR _0877_ sky130_fd_sc_hd__a211oi_1
X_1864_ _0947_ _0948_ VGND VGND VPWR VPWR _0949_ sky130_fd_sc_hd__nor2_1
XFILLER_29_206 VGND VGND VPWR VPWR sky130_fd_sc_hd__decap_6
X_1229_ _0324_ _0325_ VGND VGND VPWR VPWR _0326_ sky130_fd_sc_hd__nor2_1
XFILLER_12_139 VGND VGND VPWR VPWR sky130_fd_sc_hd__fill_1
XFILLER_28_283 VGND VGND VPWR VPWR sky130_fd_sc_hd__fill_1
XFILLER_28_294 VGND VGND VPWR VPWR sky130_fd_sc_hd__decap_4
X_1580_ _0666_ _0665_ _0667_ VGND VGND VPWR VPWR _0668_ sky130_fd_sc_hd__a21o_1
XFILLER_7_121 VGND VGND VPWR VPWR sky130_fd_sc_hd__decap_3
XFILLER_7_110 VGND VGND VPWR VPWR sky130_fd_sc_hd__fill_2
XFILLER_7_187 VGND VGND VPWR VPWR sky130_fd_sc_hd__decap_4
XFILLER_11_161 VGND VGND VPWR VPWR sky130_fd_sc_hd__decap_6
XFILLER_34_220 VPWR VGND VPWR VGND sky130_ef_sc_hd__decap_12
XFILLER_26_209 VPWR VGND VPWR VGND sky130_ef_sc_hd__decap_12
X_1014_ net31 net117 net105 VGND VGND VPWR VPWR _0972_ sky130_fd_sc_hd__and3_1
X_1847_ _0928_ _0929_ VGND VGND VPWR VPWR _0931_ sky130_fd_sc_hd__nor2_1
X_1916_ net59 _1002_ VGND VGND VPWR VPWR _1003_ sky130_fd_sc_hd__nor2_1
XFILLER_8_70 VGND VGND VPWR VPWR sky130_fd_sc_hd__decap_6
X_1778_ _0825_ _0859_ VGND VGND VPWR VPWR _0860_ sky130_fd_sc_hd__or2_1
XTAP_TAPCELL_ROW_4_135 VGND VPWR sky130_fd_sc_hd__tapvpwrvgnd_1
XFILLER_27_57 VGND VGND VPWR VPWR sky130_fd_sc_hd__decap_8
XFILLER_25_253 VPWR VGND VPWR VGND sky130_ef_sc_hd__decap_12
XTAP_TAPCELL_ROW_27_259 VGND VPWR sky130_fd_sc_hd__tapvpwrvgnd_1
Xclone33 net92 VGND VGND VPWR VPWR net158 sky130_fd_sc_hd__clkbuf_1
Xclone44 net91 VGND VGND VPWR VPWR net169 sky130_fd_sc_hd__clkbuf_1
XFILLER_48_301 VGND VGND VPWR VPWR sky130_fd_sc_hd__decap_6
XFILLER_16_253 VPWR VGND VPWR VGND sky130_ef_sc_hd__decap_12
X_1701_ _0781_ _0783_ net67 VGND VGND VPWR VPWR _0785_ sky130_fd_sc_hd__a21o_1
X_1632_ _0714_ _0715_ net73 VGND VGND VPWR VPWR _0718_ sky130_fd_sc_hd__o21ai_1
X_1494_ net80 _0583_ _0584_ net89 VGND VGND VPWR VPWR _0016_ sky130_fd_sc_hd__o211a_1
X_1563_ net81 _0650_ _0651_ net86 VGND VGND VPWR VPWR _0018_ sky130_fd_sc_hd__o211a_1
XTAP_TAPCELL_ROW_1_116 VGND VPWR sky130_fd_sc_hd__tapvpwrvgnd_1
XFILLER_22_234 VGND VGND VPWR VPWR sky130_fd_sc_hd__decap_4
XFILLER_22_256 VPWR VGND VPWR VGND sky130_ef_sc_hd__decap_12
XTAP_TAPCELL_ROW_23_240 VGND VPWR sky130_fd_sc_hd__tapvpwrvgnd_1
XFILLER_0_193 VGND VGND VPWR VPWR sky130_fd_sc_hd__decap_3
XFILLER_48_197 VPWR VGND VPWR VGND sky130_ef_sc_hd__decap_12
XTAP_TAPCELL_ROW_46_365 VGND VPWR sky130_fd_sc_hd__tapvpwrvgnd_1
X_1615_ _0701_ _0700_ _0699_ VGND VGND VPWR VPWR _0702_ sky130_fd_sc_hd__and3_4
X_1546_ net160 _0633_ _0634_ VGND VGND VPWR VPWR _0635_ sky130_fd_sc_hd__a21oi_1
X_1477_ _0564_ _0565_ _0566_ VGND VGND VPWR VPWR _0568_ sky130_fd_sc_hd__a21o_1
XFILLER_39_153 VGND VGND VPWR VPWR sky130_fd_sc_hd__fill_1
X_2029_ clknet_2_1__leaf_clk _0020_ VGND VGND VPWR VPWR net29 sky130_fd_sc_hd__dfxtp_1
XFILLER_10_226 VGND VGND VPWR VPWR sky130_fd_sc_hd__decap_8
XTAP_TAPCELL_ROW_20_221 VGND VPWR sky130_fd_sc_hd__tapvpwrvgnd_1
XFILLER_24_25 VGND VGND VPWR VPWR sky130_fd_sc_hd__decap_3
XFILLER_40_13 VPWR VGND VPWR VGND sky130_ef_sc_hd__decap_12
XFILLER_49_55 VGND VGND VPWR VPWR sky130_fd_sc_hd__fill_1
XFILLER_45_167 VGND VGND VPWR VPWR sky130_fd_sc_hd__fill_1
XFILLER_45_145 VGND VGND VPWR VPWR sky130_fd_sc_hd__decap_8
XTAP_TAPCELL_ROW_43_346 VGND VPWR sky130_fd_sc_hd__tapvpwrvgnd_1
XTAP_TAPCELL_ROW_51_390 VGND VPWR sky130_fd_sc_hd__tapvpwrvgnd_1
X_1331_ net96 net6 net109 net107 VGND VGND VPWR VPWR _0425_ sky130_fd_sc_hd__and4_1
X_1400_ _0491_ _0492_ VGND VGND VPWR VPWR _0493_ sky130_fd_sc_hd__and2b_1
XFILLER_36_134 VGND VGND VPWR VPWR sky130_fd_sc_hd__decap_6
XFILLER_36_123 VGND VGND VPWR VPWR sky130_fd_sc_hd__decap_4
X_1193_ net104 net106 _0252_ _0251_ VGND VGND VPWR VPWR _0290_ sky130_fd_sc_hd__a31o_1
X_1262_ _0350_ _0356_ _0357_ VGND VGND VPWR VPWR _0358_ sky130_fd_sc_hd__nand3_1
Xinput6 activation[5] VGND VGND VPWR VPWR net6 sky130_fd_sc_hd__dlymetal6s2s_1
XFILLER_24_307 VGND VGND VPWR VPWR sky130_fd_sc_hd__fill_1
XFILLER_51_148 VGND VGND VPWR VPWR sky130_fd_sc_hd__fill_2
XFILLER_51_104 VGND VGND VPWR VPWR sky130_fd_sc_hd__decap_8
XFILLER_10_16 VPWR VGND VPWR VGND sky130_ef_sc_hd__decap_12
X_1529_ net26 net82 _0617_ _0618_ net87 VGND VGND VPWR VPWR _0017_ sky130_fd_sc_hd__o221a_1
XFILLER_42_137 VGND VGND VPWR VPWR sky130_fd_sc_hd__decap_3
XFILLER_27_167 VGND VGND VPWR VPWR sky130_fd_sc_hd__fill_1
XFILLER_27_156 VGND VGND VPWR VPWR sky130_fd_sc_hd__decap_3
XFILLER_27_123 VGND VGND VPWR VPWR sky130_fd_sc_hd__fill_2
XPHY_EDGE_ROW_14_Right_14 VGND VGND VPWR VPWR sky130_fd_sc_hd__decap_3
XFILLER_2_277 VPWR VGND VPWR VGND sky130_ef_sc_hd__decap_12
XFILLER_2_233 VPWR VGND VPWR VGND sky130_ef_sc_hd__decap_12
XPHY_EDGE_ROW_23_Right_23 VGND VGND VPWR VPWR sky130_fd_sc_hd__decap_3
XPHY_EDGE_ROW_32_Right_32 VGND VGND VPWR VPWR sky130_fd_sc_hd__decap_3
X_1880_ _0963_ _0964_ VGND VGND VPWR VPWR _0965_ sky130_fd_sc_hd__nor2_1
XPHY_EDGE_ROW_41_Right_41 VGND VGND VPWR VPWR sky130_fd_sc_hd__decap_3
X_1314_ _0404_ _0406_ _0361_ _0364_ VGND VGND VPWR VPWR _0409_ sky130_fd_sc_hd__o211a_1
XPHY_EDGE_ROW_50_Right_50 VGND VGND VPWR VPWR sky130_fd_sc_hd__decap_3
XFILLER_49_281 VPWR VGND VPWR VGND sky130_ef_sc_hd__decap_12
X_1176_ _0257_ _0273_ VGND VGND VPWR VPWR _0274_ sky130_fd_sc_hd__nor2_1
XFILLER_2_83 VGND VGND VPWR VPWR sky130_fd_sc_hd__fill_1
X_1245_ _0339_ _0340_ VGND VGND VPWR VPWR _0341_ sky130_fd_sc_hd__xor2_1
XFILLER_24_104 VPWR VGND VPWR VGND sky130_ef_sc_hd__decap_12
XFILLER_24_137 VGND VGND VPWR VPWR sky130_fd_sc_hd__decap_3
XFILLER_21_15 VPWR VGND VPWR VGND sky130_ef_sc_hd__decap_12
XFILLER_46_89 VGND VGND VPWR VPWR sky130_fd_sc_hd__fill_1
XFILLER_15_104 VGND VGND VPWR VPWR sky130_fd_sc_hd__fill_1
XFILLER_15_148 VGND VGND VPWR VPWR sky130_fd_sc_hd__decap_3
XFILLER_46_251 VGND VGND VPWR VPWR sky130_fd_sc_hd__fill_1
X_1030_ net125 net172 _0131_ VGND VGND VPWR VPWR _0133_ sky130_fd_sc_hd__a21o_1
X_1863_ _0917_ _0919_ _0946_ VGND VGND VPWR VPWR _0948_ sky130_fd_sc_hd__nor3_1
X_1932_ _0050_ VGND VGND VPWR VPWR _0051_ sky130_fd_sc_hd__inv_2
XFILLER_14_181 VPWR VGND VPWR VGND sky130_ef_sc_hd__decap_12
XTAP_TAPCELL_ROW_16_198 VGND VPWR sky130_fd_sc_hd__tapvpwrvgnd_1
X_1794_ _0872_ _0873_ net75 VGND VGND VPWR VPWR _0876_ sky130_fd_sc_hd__o21ai_1
XFILLER_37_240 VGND VGND VPWR VPWR sky130_fd_sc_hd__fill_2
X_1228_ _0322_ _0323_ _0289_ VGND VGND VPWR VPWR _0325_ sky130_fd_sc_hd__o21a_1
XFILLER_37_284 VPWR VGND VPWR VGND sky130_ef_sc_hd__decap_12
X_1159_ _0215_ _0255_ VGND VGND VPWR VPWR _0257_ sky130_fd_sc_hd__xor2_1
XFILLER_12_107 VPWR VGND VPWR VGND sky130_ef_sc_hd__decap_12
XFILLER_32_69 VGND VGND VPWR VPWR sky130_fd_sc_hd__fill_2
XFILLER_34_232 VGND VGND VPWR VPWR sky130_fd_sc_hd__decap_8
X_1013_ net117 net104 net31 VGND VGND VPWR VPWR _0961_ sky130_fd_sc_hd__a21oi_1
X_1777_ _0856_ _0857_ VGND VGND VPWR VPWR _0859_ sky130_fd_sc_hd__xnor2_1
X_1846_ net121 net94 net38 VGND VGND VPWR VPWR _0929_ sky130_fd_sc_hd__a21oi_1
X_1915_ _0999_ _1000_ VGND VGND VPWR VPWR _1002_ sky130_fd_sc_hd__xnor2_1
XPHY_EDGE_ROW_4_Right_4 VGND VGND VPWR VPWR sky130_fd_sc_hd__decap_3
XTAP_TAPCELL_ROW_4_136 VGND VPWR sky130_fd_sc_hd__tapvpwrvgnd_1
XFILLER_27_69 VPWR VGND VPWR VGND sky130_ef_sc_hd__decap_12
Xclone23 net65 VGND VGND VPWR VPWR net148 sky130_fd_sc_hd__clkbuf_1
XFILLER_40_213 VPWR VGND VPWR VGND sky130_ef_sc_hd__decap_12
XFILLER_25_265 VGND VGND VPWR VPWR sky130_fd_sc_hd__decap_8
XFILLER_16_265 VPWR VGND VPWR VGND sky130_ef_sc_hd__decap_12
X_1631_ net73 _0714_ _0715_ VGND VGND VPWR VPWR _0717_ sky130_fd_sc_hd__or3_4
X_1700_ _0782_ net148 _0781_ VGND VGND VPWR VPWR _0784_ sky130_fd_sc_hd__or3b_1
X_1562_ net27 net82 VGND VGND VPWR VPWR _0651_ sky130_fd_sc_hd__or2_1
X_1493_ net25 net85 VGND VGND VPWR VPWR _0584_ sky130_fd_sc_hd__or2_1
XTAP_TAPCELL_ROW_1_117 VGND VPWR sky130_fd_sc_hd__tapvpwrvgnd_1
XFILLER_13_38 VGND VGND VPWR VPWR sky130_fd_sc_hd__decap_3
XFILLER_22_268 VPWR VGND VPWR VGND sky130_ef_sc_hd__decap_12
X_1829_ net59 _0912_ VGND VGND VPWR VPWR _0913_ sky130_fd_sc_hd__nor2_1
XTAP_TAPCELL_ROW_32_285 VGND VPWR sky130_fd_sc_hd__tapvpwrvgnd_1
XFILLER_38_57 VGND VGND VPWR VPWR sky130_fd_sc_hd__decap_4
XFILLER_45_305 VGND VGND VPWR VPWR sky130_fd_sc_hd__decap_4
XFILLER_13_213 VGND VGND VPWR VPWR sky130_fd_sc_hd__decap_8
XFILLER_13_279 VGND VGND VPWR VPWR sky130_fd_sc_hd__fill_1
XTAP_TAPCELL_ROW_46_366 VGND VPWR sky130_fd_sc_hd__tapvpwrvgnd_1
X_1614_ _0668_ net61 _0669_ VGND VGND VPWR VPWR _0701_ sky130_fd_sc_hd__a21bo_1
X_1545_ net67 net176 _0596_ VGND VGND VPWR VPWR _0634_ sky130_fd_sc_hd__a21o_1
X_1476_ _0564_ _0565_ _0566_ VGND VGND VPWR VPWR _0567_ sky130_fd_sc_hd__nand3_1
XFILLER_5_72 VGND VGND VPWR VPWR sky130_fd_sc_hd__decap_3
XFILLER_39_165 VGND VGND VPWR VPWR sky130_fd_sc_hd__decap_3
X_2028_ clknet_2_1__leaf_clk _0019_ VGND VGND VPWR VPWR net28 sky130_fd_sc_hd__dfxtp_1
XFILLER_24_15 VGND VGND VPWR VPWR sky130_fd_sc_hd__fill_1
XFILLER_40_25 VGND VGND VPWR VPWR sky130_fd_sc_hd__decap_3
XTAP_TAPCELL_ROW_20_222 VGND VPWR sky130_fd_sc_hd__tapvpwrvgnd_1
XFILLER_45_113 VGND VGND VPWR VPWR sky130_fd_sc_hd__decap_4
XTAP_TAPCELL_ROW_43_347 VGND VPWR sky130_fd_sc_hd__tapvpwrvgnd_1
XTAP_TAPCELL_ROW_51_391 VGND VPWR sky130_fd_sc_hd__tapvpwrvgnd_1
XFILLER_5_220 VGND VGND VPWR VPWR sky130_fd_sc_hd__decap_4
X_1261_ _0355_ _0354_ _0307_ _0309_ VGND VGND VPWR VPWR _0357_ sky130_fd_sc_hd__a211o_1
X_1330_ net16 net96 _0388_ _0346_ VGND VGND VPWR VPWR _0424_ sky130_fd_sc_hd__a31o_1
XFILLER_36_157 VGND VGND VPWR VPWR sky130_fd_sc_hd__decap_4
X_1192_ _0250_ _0254_ _0256_ VGND VGND VPWR VPWR _0289_ sky130_fd_sc_hd__a21oi_1
Xinput7 activation[6] VGND VGND VPWR VPWR net7 sky130_fd_sc_hd__clkbuf_1
X_1528_ _0615_ _0616_ net78 VGND VGND VPWR VPWR _0618_ sky130_fd_sc_hd__a21o_1
X_1459_ _0868_ net132 _0471_ _0515_ VGND VGND VPWR VPWR _0550_ sky130_fd_sc_hd__o22a_4
XFILLER_35_14 VGND VGND VPWR VPWR sky130_fd_sc_hd__fill_2
XFILLER_27_179 VGND VGND VPWR VPWR sky130_fd_sc_hd__fill_2
XFILLER_51_57 VPWR VGND VPWR VGND sky130_ef_sc_hd__decap_12
XFILLER_4_3 VGND VGND VPWR VPWR sky130_fd_sc_hd__decap_8
XFILLER_2_289 VPWR VGND VPWR VGND sky130_ef_sc_hd__decap_12
XFILLER_2_245 VGND VGND VPWR VPWR sky130_fd_sc_hd__decap_6
XFILLER_18_157 VGND VGND VPWR VPWR sky130_fd_sc_hd__decap_4
XFILLER_41_193 VPWR VGND VPWR VGND sky130_ef_sc_hd__decap_12
XFILLER_41_182 VGND VGND VPWR VPWR sky130_fd_sc_hd__decap_6
XFILLER_33_138 VPWR VGND VPWR VGND sky130_ef_sc_hd__decap_12
XFILLER_25_80 VPWR VGND VPWR VGND sky130_ef_sc_hd__decap_12
XFILLER_49_293 VPWR VGND VPWR VGND sky130_ef_sc_hd__decap_12
XFILLER_2_40 VGND VGND VPWR VPWR sky130_fd_sc_hd__fill_1
X_1244_ net103 _0868_ VGND VGND VPWR VPWR _0340_ sky130_fd_sc_hd__nor2_1
X_1313_ _0361_ _0364_ _0404_ _0406_ VGND VGND VPWR VPWR _0408_ sky130_fd_sc_hd__a211o_1
X_1175_ _0270_ _0271_ VGND VGND VPWR VPWR _0273_ sky130_fd_sc_hd__xor2_2
XFILLER_17_190 VGND VGND VPWR VPWR sky130_fd_sc_hd__fill_2
XFILLER_24_116 VGND VGND VPWR VPWR sky130_fd_sc_hd__fill_1
XFILLER_21_27 VGND VGND VPWR VPWR sky130_fd_sc_hd__fill_2
XFILLER_21_49 VGND VGND VPWR VPWR sky130_fd_sc_hd__fill_2
XPHY_EDGE_ROW_6_Left_58 VGND VGND VPWR VPWR sky130_fd_sc_hd__decap_3
XFILLER_30_119 VGND VGND VPWR VPWR sky130_fd_sc_hd__decap_3
XFILLER_30_108 VGND VGND VPWR VPWR sky130_fd_sc_hd__decap_4
XFILLER_38_219 VGND VGND VPWR VPWR sky130_fd_sc_hd__fill_2
X_1793_ net75 _0872_ _0873_ VGND VGND VPWR VPWR _0875_ sky130_fd_sc_hd__or3_1
Xinput10 rst VGND VGND VPWR VPWR net10 sky130_fd_sc_hd__buf_1
X_1862_ _0917_ _0919_ _0946_ VGND VGND VPWR VPWR _0947_ sky130_fd_sc_hd__o21a_1
X_1931_ _0951_ _0985_ VGND VGND VPWR VPWR _0050_ sky130_fd_sc_hd__and2_1
XFILLER_14_193 VGND VGND VPWR VPWR sky130_fd_sc_hd__decap_3
XTAP_TAPCELL_ROW_16_199 VGND VPWR sky130_fd_sc_hd__tapvpwrvgnd_1
XFILLER_37_230 VGND VGND VPWR VPWR sky130_fd_sc_hd__decap_3
X_1227_ _0289_ _0322_ _0323_ VGND VGND VPWR VPWR _0324_ sky130_fd_sc_hd__nor3_2
X_1158_ _0215_ _0255_ VGND VGND VPWR VPWR _0256_ sky130_fd_sc_hd__and2b_1
XFILLER_37_296 VPWR VGND VPWR VGND sky130_ef_sc_hd__decap_12
XFILLER_32_15 VPWR VGND VPWR VGND sky130_ef_sc_hd__decap_12
X_1089_ _0186_ _0187_ net114 net99 VGND VGND VPWR VPWR _0189_ sky130_fd_sc_hd__or4bb_4
XFILLER_12_119 VPWR VGND VPWR VGND sky130_ef_sc_hd__decap_12
XFILLER_20_141 VGND VGND VPWR VPWR sky130_fd_sc_hd__fill_1
XFILLER_4_307 VGND VGND VPWR VPWR sky130_fd_sc_hd__fill_1
XFILLER_20_174 VGND VGND VPWR VPWR sky130_fd_sc_hd__fill_1
XFILLER_43_222 VGND VGND VPWR VPWR sky130_fd_sc_hd__fill_2
XFILLER_7_134 VGND VGND VPWR VPWR sky130_fd_sc_hd__decap_8
XFILLER_21_6 VGND VGND VPWR VPWR sky130_fd_sc_hd__fill_2
X_1012_ net78 _0941_ _0930_ net86 VGND VGND VPWR VPWR _0002_ sky130_fd_sc_hd__o211a_1
XFILLER_34_277 VGND VGND VPWR VPWR sky130_fd_sc_hd__fill_1
XFILLER_34_211 VGND VGND VPWR VPWR sky130_fd_sc_hd__fill_2
X_1914_ _0999_ _1000_ VGND VGND VPWR VPWR _1001_ sky130_fd_sc_hd__and2_1
X_1776_ _0857_ _0856_ VGND VGND VPWR VPWR _0858_ sky130_fd_sc_hd__and2b_1
X_1845_ net38 net121 net158 VGND VGND VPWR VPWR _0928_ sky130_fd_sc_hd__and3_1
XFILLER_8_50 VGND VGND VPWR VPWR sky130_fd_sc_hd__decap_6
XTAP_TAPCELL_ROW_12_180 VGND VPWR sky130_fd_sc_hd__tapvpwrvgnd_1
XFILLER_25_233 VGND VGND VPWR VPWR sky130_fd_sc_hd__fill_1
XFILLER_40_225 VGND VGND VPWR VPWR sky130_fd_sc_hd__decap_8
XFILLER_31_203 VPWR VGND VPWR VGND sky130_ef_sc_hd__decap_12
XPHY_EDGE_ROW_9_Left_61 VGND VGND VPWR VPWR sky130_fd_sc_hd__decap_3
XFILLER_16_277 VPWR VGND VPWR VGND sky130_ef_sc_hd__decap_12
X_1630_ net73 _0714_ _0715_ VGND VGND VPWR VPWR _0716_ sky130_fd_sc_hd__nor3_1
XFILLER_33_80 VGND VGND VPWR VPWR sky130_fd_sc_hd__fill_1
X_1492_ _0580_ _0582_ VGND VGND VPWR VPWR _0583_ sky130_fd_sc_hd__xnor2_1
X_1561_ net138 _0649_ VGND VGND VPWR VPWR _0650_ sky130_fd_sc_hd__xnor2_1
XTAP_TAPCELL_ROW_1_118 VGND VPWR sky130_fd_sc_hd__tapvpwrvgnd_1
XTAP_TAPCELL_ROW_32_286 VGND VPWR sky130_fd_sc_hd__tapvpwrvgnd_1
XFILLER_22_247 VGND VGND VPWR VPWR sky130_fd_sc_hd__decap_4
X_1759_ net75 _0838_ _0839_ VGND VGND VPWR VPWR _0841_ sky130_fd_sc_hd__or3_1
X_1828_ _0910_ _0911_ VGND VGND VPWR VPWR _0912_ sky130_fd_sc_hd__xnor2_1
XFILLER_13_225 VPWR VGND VPWR VGND sky130_ef_sc_hd__decap_12
XPHY_EDGE_ROW_35_Left_87 VGND VGND VPWR VPWR sky130_fd_sc_hd__decap_3
XTAP_TAPCELL_ROW_46_367 VGND VPWR sky130_fd_sc_hd__tapvpwrvgnd_1
X_1613_ _0698_ _0697_ net61 VGND VGND VPWR VPWR _0700_ sky130_fd_sc_hd__a21o_1
X_1544_ _0629_ _0631_ net66 VGND VGND VPWR VPWR _0633_ sky130_fd_sc_hd__a21o_1
XFILLER_8_251 VGND VGND VPWR VPWR sky130_fd_sc_hd__fill_1
X_1475_ net68 _0528_ _0529_ VGND VGND VPWR VPWR _0566_ sky130_fd_sc_hd__a21o_1
XFILLER_27_306 VGND VGND VPWR VPWR sky130_fd_sc_hd__decap_3
XFILLER_39_199 VGND VGND VPWR VPWR sky130_fd_sc_hd__decap_4
X_2027_ clknet_2_1__leaf_clk _0018_ VGND VGND VPWR VPWR net27 sky130_fd_sc_hd__dfxtp_1
XFILLER_10_239 VPWR VGND VPWR VGND sky130_ef_sc_hd__decap_12
XTAP_TAPCELL_ROW_20_223 VGND VPWR sky130_fd_sc_hd__tapvpwrvgnd_1
XFILLER_49_57 VGND VGND VPWR VPWR sky130_fd_sc_hd__decap_3
XFILLER_45_169 VGND VGND VPWR VPWR sky130_fd_sc_hd__decap_6
XTAP_TAPCELL_ROW_43_348 VGND VPWR sky130_fd_sc_hd__tapvpwrvgnd_1
XTAP_TAPCELL_ROW_51_392 VGND VPWR sky130_fd_sc_hd__tapvpwrvgnd_1
Xinput8 activation[7] VGND VGND VPWR VPWR net8 sky130_fd_sc_hd__buf_6
X_1191_ _0218_ _0278_ _0277_ VGND VGND VPWR VPWR _0288_ sky130_fd_sc_hd__a21o_1
X_1260_ _0307_ _0309_ net161 _0355_ VGND VGND VPWR VPWR _0356_ sky130_fd_sc_hd__o211ai_2
X_1527_ _0615_ _0616_ VGND VGND VPWR VPWR _0617_ sky130_fd_sc_hd__nor2_1
XFILLER_10_29 VPWR VGND VPWR VGND sky130_ef_sc_hd__decap_12
X_1389_ net72 _0480_ _0481_ VGND VGND VPWR VPWR _0482_ sky130_fd_sc_hd__nor3_1
XFILLER_27_103 VGND VGND VPWR VPWR sky130_fd_sc_hd__fill_1
X_1458_ _0514_ _0521_ _0520_ VGND VGND VPWR VPWR _0549_ sky130_fd_sc_hd__a21o_1
XFILLER_42_106 VGND VGND VPWR VPWR sky130_fd_sc_hd__decap_4
XTAP_TAPCELL_ROW_40_329 VGND VPWR sky130_fd_sc_hd__tapvpwrvgnd_1
XFILLER_51_69 VGND VGND VPWR VPWR sky130_fd_sc_hd__decap_3
XFILLER_26_180 VPWR VGND VPWR VGND sky130_ef_sc_hd__decap_12
XFILLER_18_114 VGND VGND VPWR VPWR sky130_fd_sc_hd__decap_4
XFILLER_18_169 VGND VGND VPWR VPWR sky130_fd_sc_hd__decap_4
XFILLER_25_92 VGND VGND VPWR VPWR sky130_fd_sc_hd__decap_6
XPHY_EDGE_ROW_38_Left_90 VGND VGND VPWR VPWR sky130_fd_sc_hd__decap_3
X_1174_ _0270_ _0271_ VGND VGND VPWR VPWR _0272_ sky130_fd_sc_hd__and2b_1
X_1312_ _0361_ _0364_ _0404_ _0406_ VGND VGND VPWR VPWR _0407_ sky130_fd_sc_hd__a211oi_1
X_1243_ _0337_ _0338_ VGND VGND VPWR VPWR _0339_ sky130_fd_sc_hd__nor2_1
XPHY_EDGE_ROW_22_Left_74 VGND VGND VPWR VPWR sky130_fd_sc_hd__decap_3
XFILLER_32_161 VPWR VGND VPWR VGND sky130_ef_sc_hd__decap_12
XFILLER_7_305 VGND VGND VPWR VPWR sky130_fd_sc_hd__decap_4
XFILLER_11_50 VGND VGND VPWR VPWR sky130_fd_sc_hd__fill_1
XFILLER_11_94 VGND VGND VPWR VPWR sky130_fd_sc_hd__fill_1
XFILLER_46_253 VPWR VGND VPWR VGND sky130_ef_sc_hd__decap_12
X_1930_ _0950_ _0982_ VGND VGND VPWR VPWR _0049_ sky130_fd_sc_hd__nor2_1
XFILLER_14_150 VGND VGND VPWR VPWR sky130_fd_sc_hd__decap_8
X_1792_ net76 _0872_ _0873_ VGND VGND VPWR VPWR _0874_ sky130_fd_sc_hd__nor3_1
X_1861_ net56 _0945_ VGND VGND VPWR VPWR _0946_ sky130_fd_sc_hd__xnor2_1
Xinput11 valid_in VGND VGND VPWR VPWR net11 sky130_fd_sc_hd__clkbuf_1
XFILLER_37_253 VGND VGND VPWR VPWR sky130_fd_sc_hd__fill_1
X_1226_ _0320_ _0321_ _0272_ _0274_ VGND VGND VPWR VPWR _0323_ sky130_fd_sc_hd__a211oi_2
X_1157_ _0250_ _0254_ VGND VGND VPWR VPWR _0255_ sky130_fd_sc_hd__xor2_1
XFILLER_32_27 VGND VGND VPWR VPWR sky130_fd_sc_hd__fill_1
X_1088_ net47 net116 net98 VGND VGND VPWR VPWR _0188_ sky130_fd_sc_hd__nand3_1
XFILLER_20_197 VGND VGND VPWR VPWR sky130_fd_sc_hd__decap_6
XFILLER_28_231 VPWR VGND VPWR VGND sky130_ef_sc_hd__decap_12
XFILLER_7_113 VGND VGND VPWR VPWR sky130_fd_sc_hd__fill_1
XFILLER_11_131 VGND VGND VPWR VPWR sky130_fd_sc_hd__decap_4
XTAP_TAPCELL_ROW_29_270 VGND VPWR sky130_fd_sc_hd__tapvpwrvgnd_1
X_1011_ net20 net117 net124 VGND VGND VPWR VPWR _0941_ sky130_fd_sc_hd__nand3_1
XFILLER_34_289 VGND VGND VPWR VPWR sky130_fd_sc_hd__fill_1
X_1913_ _0965_ _0966_ _0968_ VGND VGND VPWR VPWR _1000_ sky130_fd_sc_hd__a21o_1
X_1775_ _0821_ _0822_ VGND VGND VPWR VPWR _0857_ sky130_fd_sc_hd__and2_1
X_1844_ net37 net85 _0927_ _0926_ net89 VGND VGND VPWR VPWR _0027_ sky130_fd_sc_hd__o221a_1
XFILLER_8_95 VGND VGND VPWR VPWR sky130_fd_sc_hd__fill_2
X_1209_ net115 net91 VGND VGND VPWR VPWR _0306_ sky130_fd_sc_hd__nand2_4
XFILLER_25_212 VPWR VGND VPWR VGND sky130_ef_sc_hd__decap_12
Xclone47 net113 VGND VGND VPWR VPWR net172 sky130_fd_sc_hd__clkbuf_1
XFILLER_31_215 VGND VGND VPWR VPWR sky130_fd_sc_hd__decap_6
XFILLER_16_234 VGND VGND VPWR VPWR sky130_fd_sc_hd__decap_8
XFILLER_16_289 VGND VGND VPWR VPWR sky130_fd_sc_hd__fill_1
X_1560_ _0647_ _0648_ VGND VGND VPWR VPWR _0649_ sky130_fd_sc_hd__nand2b_1
X_1491_ _0544_ _0581_ VGND VGND VPWR VPWR _0582_ sky130_fd_sc_hd__nand2_1
XFILLER_3_193 VPWR VGND VPWR VGND sky130_ef_sc_hd__decap_12
XTAP_TAPCELL_ROW_1_119 VGND VPWR sky130_fd_sc_hd__tapvpwrvgnd_1
X_1827_ net148 _0877_ _0878_ VGND VGND VPWR VPWR _0911_ sky130_fd_sc_hd__o21bai_1
XTAP_TAPCELL_ROW_32_287 VGND VPWR sky130_fd_sc_hd__tapvpwrvgnd_1
X_1758_ net75 _0838_ _0839_ VGND VGND VPWR VPWR _0840_ sky130_fd_sc_hd__nor3_1
X_1689_ _0768_ _0772_ VGND VGND VPWR VPWR _0774_ sky130_fd_sc_hd__nand2b_1
XFILLER_38_15 VPWR VGND VPWR VGND sky130_ef_sc_hd__decap_12
XFILLER_13_204 VGND VGND VPWR VPWR sky130_fd_sc_hd__fill_1
XFILLER_13_237 VPWR VGND VPWR VGND sky130_ef_sc_hd__decap_12
XFILLER_21_292 VGND VGND VPWR VPWR sky130_fd_sc_hd__fill_1
XFILLER_0_141 VGND VGND VPWR VPWR sky130_fd_sc_hd__fill_1
XFILLER_48_156 VPWR VGND VPWR VGND sky130_ef_sc_hd__decap_12
X_1612_ net61 _0697_ _0698_ VGND VGND VPWR VPWR _0699_ sky130_fd_sc_hd__nand3_1
X_1543_ _0630_ net64 _0629_ VGND VGND VPWR VPWR _0632_ sky130_fd_sc_hd__or3b_4
X_1474_ _0561_ _0563_ net67 VGND VGND VPWR VPWR _0565_ sky130_fd_sc_hd__a21o_1
XFILLER_39_101 VGND VGND VPWR VPWR sky130_fd_sc_hd__decap_8
XTAP_TAPCELL_ROW_37_313 VGND VPWR sky130_fd_sc_hd__tapvpwrvgnd_1
X_2026_ clknet_2_1__leaf_clk _0017_ VGND VGND VPWR VPWR net26 sky130_fd_sc_hd__dfxtp_1
XTAP_TAPCELL_ROW_20_224 VGND VPWR sky130_fd_sc_hd__tapvpwrvgnd_1
XFILLER_45_159 VGND VGND VPWR VPWR sky130_fd_sc_hd__decap_8
XTAP_TAPCELL_ROW_51_393 VGND VPWR sky130_fd_sc_hd__tapvpwrvgnd_1
XTAP_TAPCELL_ROW_43_349 VGND VPWR sky130_fd_sc_hd__tapvpwrvgnd_1
XFILLER_5_277 VGND VGND VPWR VPWR sky130_fd_sc_hd__decap_3
XFILLER_36_115 VGND VGND VPWR VPWR sky130_fd_sc_hd__fill_1
Xinput9 en VGND VGND VPWR VPWR net9 sky130_fd_sc_hd__clkbuf_1
X_1190_ net79 _0286_ _0287_ net88 VGND VGND VPWR VPWR _0009_ sky130_fd_sc_hd__o211a_1
XFILLER_44_170 VGND VGND VPWR VPWR sky130_fd_sc_hd__decap_3
X_1457_ net24 net85 _0547_ _0548_ net88 VGND VGND VPWR VPWR _0015_ sky130_fd_sc_hd__o221a_1
X_1526_ _0581_ _0580_ _0544_ _0579_ VGND VGND VPWR VPWR _0616_ sky130_fd_sc_hd__a31oi_1
XFILLER_35_38 VPWR VGND VPWR VGND sky130_ef_sc_hd__decap_12
X_1388_ net119 net91 net23 VGND VGND VPWR VPWR _0481_ sky130_fd_sc_hd__a21oi_1
XFILLER_27_148 VGND VGND VPWR VPWR sky130_fd_sc_hd__decap_8
XFILLER_51_15 VPWR VGND VPWR VGND sky130_ef_sc_hd__decap_12
X_2009_ clknet_2_1__leaf_clk net10 VGND VGND VPWR VPWR rst_prev sky130_fd_sc_hd__dfxtp_1
XFILLER_26_192 VGND VGND VPWR VPWR sky130_fd_sc_hd__decap_4
XFILLER_41_92 VGND VGND VPWR VPWR sky130_fd_sc_hd__decap_3
X_1311_ _0402_ _0403_ _0387_ VGND VGND VPWR VPWR _0406_ sky130_fd_sc_hd__a21oi_1
X_1173_ _0225_ _0232_ _0231_ VGND VGND VPWR VPWR _0271_ sky130_fd_sc_hd__a21bo_1
XFILLER_2_53 VGND VGND VPWR VPWR sky130_fd_sc_hd__fill_1
XPHY_EDGE_ROW_10_Right_10 VGND VGND VPWR VPWR sky130_fd_sc_hd__decap_3
X_1242_ net5 net108 net106 net101 VGND VGND VPWR VPWR _0338_ sky130_fd_sc_hd__a22oi_1
XFILLER_32_173 VGND VGND VPWR VPWR sky130_fd_sc_hd__fill_1
XFILLER_24_129 VGND VGND VPWR VPWR sky130_fd_sc_hd__decap_8
XFILLER_46_15 VPWR VGND VPWR VGND sky130_ef_sc_hd__decap_12
X_1509_ net176 _0597_ net67 VGND VGND VPWR VPWR _0599_ sky130_fd_sc_hd__a21o_1
XFILLER_46_265 VPWR VGND VPWR VGND sky130_ef_sc_hd__decap_12
XFILLER_46_232 VGND VGND VPWR VPWR sky130_fd_sc_hd__decap_4
X_1860_ _0942_ _0943_ VGND VGND VPWR VPWR _0945_ sky130_fd_sc_hd__xnor2_1
Xinput12 weight[0] VGND VGND VPWR VPWR net12 sky130_fd_sc_hd__clkbuf_1
X_1791_ net122 net95 net36 VGND VGND VPWR VPWR _0873_ sky130_fd_sc_hd__a21oi_1
XFILLER_37_265 VGND VGND VPWR VPWR sky130_fd_sc_hd__decap_6
XFILLER_37_221 VGND VGND VPWR VPWR sky130_fd_sc_hd__decap_3
X_1225_ _0272_ _0274_ _0320_ _0321_ VGND VGND VPWR VPWR _0322_ sky130_fd_sc_hd__o211a_1
X_1156_ _0214_ _0253_ VGND VGND VPWR VPWR _0254_ sky130_fd_sc_hd__xnor2_1
X_1087_ net47 net116 net98 VGND VGND VPWR VPWR _0187_ sky130_fd_sc_hd__and3_1
XFILLER_20_165 VGND VGND VPWR VPWR sky130_fd_sc_hd__decap_4
X_1989_ _0048_ _0084_ net126 _0110_ VGND VGND VPWR VPWR _0111_ sky130_fd_sc_hd__o31ai_4
XFILLER_28_243 VGND VGND VPWR VPWR sky130_fd_sc_hd__decap_4
XFILLER_43_279 VGND VGND VPWR VPWR sky130_fd_sc_hd__fill_1
XFILLER_43_235 VPWR VGND VPWR VGND sky130_ef_sc_hd__decap_12
XFILLER_43_213 VGND VGND VPWR VPWR sky130_fd_sc_hd__fill_1
XFILLER_11_110 VGND VGND VPWR VPWR sky130_fd_sc_hd__fill_2
XFILLER_7_169 VGND VGND VPWR VPWR sky130_fd_sc_hd__decap_4
XTAP_TAPCELL_ROW_29_271 VGND VPWR sky130_fd_sc_hd__tapvpwrvgnd_1
XFILLER_19_243 VPWR VGND VPWR VGND sky130_ef_sc_hd__decap_12
X_1010_ net117 net124 net82 net204 VGND VGND VPWR VPWR _0930_ sky130_fd_sc_hd__a31o_1
X_1843_ _0896_ _0899_ _0925_ net80 VGND VGND VPWR VPWR _0927_ sky130_fd_sc_hd__a31o_1
X_1912_ _0997_ _0998_ VGND VGND VPWR VPWR _0999_ sky130_fd_sc_hd__nor2_1
X_1774_ net63 _0855_ VGND VGND VPWR VPWR _0856_ sky130_fd_sc_hd__xnor2_1
X_1208_ _0303_ _0304_ VGND VGND VPWR VPWR _0305_ sky130_fd_sc_hd__xnor2_1
XFILLER_27_39 VPWR VGND VPWR VGND sky130_ef_sc_hd__decap_12
XFILLER_43_49 VGND VGND VPWR VPWR sky130_fd_sc_hd__decap_6
X_1139_ _0219_ _0236_ _0237_ VGND VGND VPWR VPWR _0238_ sky130_fd_sc_hd__and3_1
Xclone15 net141 VGND VGND VPWR VPWR net140 sky130_fd_sc_hd__clkbuf_1
XFILLER_4_139 VGND VGND VPWR VPWR sky130_fd_sc_hd__fill_1
XTAP_TAPCELL_ROW_18_208 VGND VPWR sky130_fd_sc_hd__tapvpwrvgnd_1
XTAP_TAPCELL_ROW_26_252 VGND VPWR sky130_fd_sc_hd__tapvpwrvgnd_1
X_1490_ _0505_ _0510_ _0545_ VGND VGND VPWR VPWR _0581_ sky130_fd_sc_hd__nand3_1
XFILLER_3_161 VGND VGND VPWR VPWR sky130_fd_sc_hd__decap_6
X_2042_ clknet_2_2__leaf_clk _0033_ VGND VGND VPWR VPWR net44 sky130_fd_sc_hd__dfxtp_1
XPHY_EDGE_ROW_8_Right_8 VGND VGND VPWR VPWR sky130_fd_sc_hd__decap_3
X_1826_ net148 _0909_ VGND VGND VPWR VPWR _0910_ sky130_fd_sc_hd__xnor2_1
XTAP_TAPCELL_ROW_32_288 VGND VPWR sky130_fd_sc_hd__tapvpwrvgnd_1
X_1757_ net122 net94 net35 VGND VGND VPWR VPWR _0839_ sky130_fd_sc_hd__a21oi_1
XPHY_EDGE_ROW_39_Right_39 VGND VGND VPWR VPWR sky130_fd_sc_hd__decap_3
X_1688_ _0772_ _0768_ VGND VGND VPWR VPWR _0773_ sky130_fd_sc_hd__nand2b_1
XFILLER_38_27 VGND VGND VPWR VPWR sky130_fd_sc_hd__fill_1
XPHY_EDGE_ROW_48_Right_48 VGND VGND VPWR VPWR sky130_fd_sc_hd__decap_3
XFILLER_13_249 VPWR VGND VPWR VGND sky130_ef_sc_hd__decap_12
XFILLER_48_168 VGND VGND VPWR VPWR sky130_fd_sc_hd__decap_4
XFILLER_0_120 VPWR VGND VPWR VGND sky130_ef_sc_hd__decap_12
XFILLER_0_197 VPWR VGND VPWR VGND sky130_ef_sc_hd__decap_12
X_1611_ _0694_ _0695_ _0696_ VGND VGND VPWR VPWR _0698_ sky130_fd_sc_hd__nand3_1
XFILLER_8_253 VPWR VGND VPWR VGND sky130_ef_sc_hd__decap_12
X_1542_ _0590_ _0592_ _0627_ _0628_ VGND VGND VPWR VPWR _0631_ sky130_fd_sc_hd__o211ai_1
X_1473_ _0562_ net65 _0561_ VGND VGND VPWR VPWR _0564_ sky130_fd_sc_hd__or3b_1
XFILLER_5_53 VGND VGND VPWR VPWR sky130_fd_sc_hd__decap_3
XFILLER_5_31 VGND VGND VPWR VPWR sky130_fd_sc_hd__decap_4
XFILLER_39_113 VGND VGND VPWR VPWR sky130_fd_sc_hd__decap_3
XTAP_TAPCELL_ROW_37_314 VGND VPWR sky130_fd_sc_hd__tapvpwrvgnd_1
X_2025_ clknet_2_3__leaf_clk _0016_ VGND VGND VPWR VPWR net25 sky130_fd_sc_hd__dfxtp_1
X_1809_ _0892_ _0891_ VGND VGND VPWR VPWR _0893_ sky130_fd_sc_hd__and2b_1
XFILLER_49_15 VPWR VGND VPWR VGND sky130_ef_sc_hd__decap_12
XFILLER_45_127 VGND VGND VPWR VPWR sky130_fd_sc_hd__fill_2
XTAP_TAPCELL_ROW_51_394 VGND VPWR sky130_fd_sc_hd__tapvpwrvgnd_1
XFILLER_14_95 VGND VGND VPWR VPWR sky130_fd_sc_hd__fill_1
XFILLER_30_61 VGND VGND VPWR VPWR sky130_fd_sc_hd__decap_8
XFILLER_5_245 VPWR VGND VPWR VGND sky130_ef_sc_hd__decap_12
X_1456_ _0513_ _0546_ net80 VGND VGND VPWR VPWR _0548_ sky130_fd_sc_hd__a21o_1
X_1525_ _0613_ _0614_ VGND VGND VPWR VPWR _0615_ sky130_fd_sc_hd__and2b_1
X_1387_ net23 net119 net91 VGND VGND VPWR VPWR _0480_ sky130_fd_sc_hd__and3_4
X_2008_ clknet_2_1__leaf_clk _0000_ VGND VGND VPWR VPWR net53 sky130_fd_sc_hd__dfxtp_1
XFILLER_35_28 VGND VGND VPWR VPWR sky130_fd_sc_hd__decap_6
XFILLER_51_49 VGND VGND VPWR VPWR sky130_fd_sc_hd__decap_3
XFILLER_51_27 VGND VGND VPWR VPWR sky130_fd_sc_hd__fill_1
XFILLER_50_141 VGND VGND VPWR VPWR sky130_fd_sc_hd__fill_2
XFILLER_18_105 VGND VGND VPWR VPWR sky130_fd_sc_hd__fill_1
XFILLER_33_119 VGND VGND VPWR VPWR sky130_fd_sc_hd__fill_2
XFILLER_26_160 VGND VGND VPWR VPWR sky130_fd_sc_hd__fill_1
XFILLER_49_230 VPWR VGND VPWR VGND sky130_ef_sc_hd__decap_12
XFILLER_44_7 VGND VGND VPWR VPWR sky130_fd_sc_hd__decap_3
XFILLER_1_281 VPWR VGND VPWR VGND sky130_ef_sc_hd__decap_12
X_1241_ net101 net99 net108 net106 VGND VGND VPWR VPWR _0337_ sky130_fd_sc_hd__and4_1
X_1310_ _0387_ _0402_ _0403_ VGND VGND VPWR VPWR _0405_ sky130_fd_sc_hd__nand3_2
X_1172_ _0261_ _0269_ VGND VGND VPWR VPWR _0270_ sky130_fd_sc_hd__xnor2_1
XFILLER_32_141 VGND VGND VPWR VPWR sky130_fd_sc_hd__decap_3
XFILLER_46_27 VGND VGND VPWR VPWR sky130_fd_sc_hd__fill_1
X_1508_ net64 _0596_ _0595_ VGND VGND VPWR VPWR _0598_ sky130_fd_sc_hd__or3b_4
X_1439_ _0529_ net65 _0528_ VGND VGND VPWR VPWR _0531_ sky130_fd_sc_hd__or3b_1
XFILLER_15_108 VGND VGND VPWR VPWR sky130_fd_sc_hd__decap_4
XFILLER_2_3 VPWR VGND VPWR VGND sky130_ef_sc_hd__decap_12
XFILLER_46_277 VPWR VGND VPWR VGND sky130_ef_sc_hd__decap_12
X_1790_ net36 net122 net94 VGND VGND VPWR VPWR _0872_ sky130_fd_sc_hd__and3_1
Xinput13 weight[1] VGND VGND VPWR VPWR net13 sky130_fd_sc_hd__clkbuf_1
XFILLER_35_3 VGND VGND VPWR VPWR sky130_fd_sc_hd__fill_2
X_1224_ _0318_ _0319_ _0300_ VGND VGND VPWR VPWR _0321_ sky130_fd_sc_hd__a21o_1
X_1155_ _0251_ _0252_ VGND VGND VPWR VPWR _0253_ sky130_fd_sc_hd__and2b_1
X_1086_ net116 net98 net47 VGND VGND VPWR VPWR _0186_ sky130_fd_sc_hd__a21oi_1
X_1988_ _0041_ _0082_ _0109_ VGND VGND VPWR VPWR _0110_ sky130_fd_sc_hd__o21ai_1
XFILLER_20_111 VPWR VGND VPWR VGND sky130_ef_sc_hd__decap_12
XTAP_TAPCELL_ROW_7_148 VGND VPWR sky130_fd_sc_hd__tapvpwrvgnd_1
XFILLER_43_225 VGND VGND VPWR VPWR sky130_fd_sc_hd__decap_4
Xclkbuf_2_2__f_clk clknet_0_clk VGND VGND VPWR VPWR clknet_2_2__leaf_clk sky130_fd_sc_hd__clkbuf_16
XFILLER_43_247 VPWR VGND VPWR VGND sky130_ef_sc_hd__decap_12
XFILLER_22_95 VGND VGND VPWR VPWR sky130_fd_sc_hd__decap_4
XFILLER_34_247 VGND VGND VPWR VPWR sky130_fd_sc_hd__decap_4
XTAP_TAPCELL_ROW_29_272 VGND VPWR sky130_fd_sc_hd__tapvpwrvgnd_1
XFILLER_19_255 VPWR VGND VPWR VGND sky130_ef_sc_hd__decap_12
X_1773_ _0853_ _0854_ VGND VGND VPWR VPWR _0855_ sky130_fd_sc_hd__nand2_1
X_1842_ _0896_ _0899_ _0925_ VGND VGND VPWR VPWR _0926_ sky130_fd_sc_hd__a21oi_1
X_1911_ net140 _0996_ VGND VGND VPWR VPWR _0998_ sky130_fd_sc_hd__and2_1
X_1207_ net99 net110 VGND VGND VPWR VPWR _0304_ sky130_fd_sc_hd__nand2_1
XFILLER_33_291 VGND VGND VPWR VPWR sky130_fd_sc_hd__decap_3
X_1138_ _0233_ _0234_ _0235_ VGND VGND VPWR VPWR _0237_ sky130_fd_sc_hd__a21o_1
X_1069_ net114 net101 _0165_ _0167_ VGND VGND VPWR VPWR _0170_ sky130_fd_sc_hd__a22o_1
XFILLER_25_225 VGND VGND VPWR VPWR sky130_fd_sc_hd__decap_8
XFILLER_4_129 VGND VGND VPWR VPWR sky130_fd_sc_hd__fill_1
XTAP_TAPCELL_ROW_18_209 VGND VPWR sky130_fd_sc_hd__tapvpwrvgnd_1
XTAP_TAPCELL_ROW_26_253 VGND VPWR sky130_fd_sc_hd__tapvpwrvgnd_1
XFILLER_33_61 VGND VGND VPWR VPWR sky130_fd_sc_hd__fill_1
XFILLER_39_306 VGND VGND VPWR VPWR sky130_fd_sc_hd__decap_3
X_2041_ clknet_2_2__leaf_clk _0032_ VGND VGND VPWR VPWR net43 sky130_fd_sc_hd__dfxtp_1
X_1756_ net35 net122 net94 VGND VGND VPWR VPWR _0838_ sky130_fd_sc_hd__and3_1
X_1825_ _0907_ _0908_ VGND VGND VPWR VPWR _0909_ sky130_fd_sc_hd__nor2_1
XTAP_TAPCELL_ROW_32_289 VGND VPWR sky130_fd_sc_hd__tapvpwrvgnd_1
XFILLER_30_283 VPWR VGND VPWR VGND sky130_ef_sc_hd__decap_12
X_1687_ _0771_ net139 _0770_ VGND VGND VPWR VPWR _0772_ sky130_fd_sc_hd__a21oi_2
XTAP_TAPCELL_ROW_0_110 VGND VPWR sky130_fd_sc_hd__tapvpwrvgnd_1
XFILLER_0_110 VGND VGND VPWR VPWR sky130_fd_sc_hd__fill_2
XFILLER_28_83 VGND VGND VPWR VPWR sky130_fd_sc_hd__fill_1
XFILLER_0_132 VGND VGND VPWR VPWR sky130_fd_sc_hd__decap_8
XFILLER_0_154 VPWR VGND VPWR VGND sky130_ef_sc_hd__decap_12
XFILLER_44_93 VGND VGND VPWR VPWR sky130_fd_sc_hd__decap_3
X_1610_ _0695_ _0694_ _0696_ VGND VGND VPWR VPWR _0697_ sky130_fd_sc_hd__a21o_1
XFILLER_8_265 VPWR VGND VPWR VGND sky130_ef_sc_hd__decap_12
X_1541_ _0590_ _0592_ _0627_ _0628_ VGND VGND VPWR VPWR _0630_ sky130_fd_sc_hd__o211a_1
X_1472_ _0523_ _0525_ _0559_ _0560_ VGND VGND VPWR VPWR _0563_ sky130_fd_sc_hd__o211ai_1
XFILLER_47_191 VPWR VGND VPWR VGND sky130_ef_sc_hd__decap_12
XFILLER_39_169 VGND VGND VPWR VPWR sky130_fd_sc_hd__decap_3
XFILLER_39_136 VGND VGND VPWR VPWR sky130_fd_sc_hd__decap_3
XTAP_TAPCELL_ROW_37_315 VGND VPWR sky130_fd_sc_hd__tapvpwrvgnd_1
X_2024_ clknet_2_3__leaf_clk _0015_ VGND VGND VPWR VPWR net24 sky130_fd_sc_hd__dfxtp_1
XFILLER_50_301 VGND VGND VPWR VPWR sky130_fd_sc_hd__decap_6
XFILLER_49_27 VPWR VGND VPWR VGND sky130_ef_sc_hd__decap_12
X_1808_ net63 _0853_ _0854_ VGND VGND VPWR VPWR _0892_ sky130_fd_sc_hd__a21boi_1
X_1739_ _0585_ _0820_ _0821_ VGND VGND VPWR VPWR _0822_ sky130_fd_sc_hd__nand3_1
XFILLER_40_29 VPWR VGND VPWR VGND sky130_ef_sc_hd__decap_12
XFILLER_45_106 VGND VGND VPWR VPWR sky130_fd_sc_hd__decap_6
XTAP_TAPCELL_ROW_51_395 VGND VPWR sky130_fd_sc_hd__tapvpwrvgnd_1
XFILLER_14_85 VGND VGND VPWR VPWR sky130_fd_sc_hd__fill_2
XFILLER_5_257 VPWR VGND VPWR VGND sky130_ef_sc_hd__decap_12
XFILLER_44_183 VPWR VGND VPWR VGND sky130_ef_sc_hd__decap_12
XTAP_TAPCELL_ROW_42_340 VGND VPWR sky130_fd_sc_hd__tapvpwrvgnd_1
X_1524_ _0612_ _0611_ _0576_ VGND VGND VPWR VPWR _0614_ sky130_fd_sc_hd__a21o_1
X_1455_ _0513_ _0546_ VGND VGND VPWR VPWR _0547_ sky130_fd_sc_hd__nor2_1
X_1386_ _0468_ _0477_ VGND VGND VPWR VPWR _0479_ sky130_fd_sc_hd__xnor2_1
X_2007_ net79 _0127_ _0128_ net88 VGND VGND VPWR VPWR _0033_ sky130_fd_sc_hd__o211a_1
XFILLER_27_139 VGND VGND VPWR VPWR sky130_fd_sc_hd__decap_3
XFILLER_50_197 VGND VGND VPWR VPWR sky130_fd_sc_hd__decap_3
XFILLER_50_175 VGND VGND VPWR VPWR sky130_fd_sc_hd__fill_1
XFILLER_18_139 VGND VGND VPWR VPWR sky130_fd_sc_hd__fill_1
XFILLER_41_153 VPWR VGND VPWR VGND sky130_ef_sc_hd__decap_12
XFILLER_14_301 VGND VGND VPWR VPWR sky130_fd_sc_hd__decap_6
XFILLER_41_72 VPWR VGND VPWR VGND sky130_ef_sc_hd__decap_12
XFILLER_49_242 VPWR VGND VPWR VGND sky130_ef_sc_hd__decap_12
XFILLER_1_293 VPWR VGND VPWR VGND sky130_ef_sc_hd__decap_12
X_1171_ _0266_ _0267_ VGND VGND VPWR VPWR _0269_ sky130_fd_sc_hd__xor2_1
X_1240_ _0302_ _0304_ _0301_ VGND VGND VPWR VPWR _0336_ sky130_fd_sc_hd__o21ba_1
XFILLER_2_99 VGND VGND VPWR VPWR sky130_fd_sc_hd__decap_4
XFILLER_32_197 VGND VGND VPWR VPWR sky130_fd_sc_hd__fill_1
X_1507_ _0556_ _0558_ _0593_ _0594_ VGND VGND VPWR VPWR _0597_ sky130_fd_sc_hd__o211ai_1
X_1438_ _0480_ _0482_ _0526_ _0527_ VGND VGND VPWR VPWR _0530_ sky130_fd_sc_hd__o211ai_1
X_1369_ _0459_ _0461_ VGND VGND VPWR VPWR _0463_ sky130_fd_sc_hd__nor2_1
XFILLER_23_186 VPWR VGND VPWR VGND sky130_ef_sc_hd__decap_12
XFILLER_46_289 VPWR VGND VPWR VGND sky130_ef_sc_hd__decap_12
Xinput14 weight[2] VGND VGND VPWR VPWR net14 sky130_fd_sc_hd__buf_6
XPHY_EDGE_ROW_26_Left_78 VGND VGND VPWR VPWR sky130_fd_sc_hd__decap_3
X_1154_ net100 net110 net108 net102 VGND VGND VPWR VPWR _0252_ sky130_fd_sc_hd__a22o_1
X_1223_ _0300_ _0318_ _0319_ VGND VGND VPWR VPWR _0320_ sky130_fd_sc_hd__nand3_2
XFILLER_37_278 VGND VGND VPWR VPWR sky130_fd_sc_hd__fill_2
X_1085_ _0164_ _0172_ _0171_ VGND VGND VPWR VPWR _0185_ sky130_fd_sc_hd__a21o_1
XFILLER_20_123 VPWR VGND VPWR VGND sky130_ef_sc_hd__decap_12
X_1987_ _0041_ _0082_ _0044_ VGND VGND VPWR VPWR _0109_ sky130_fd_sc_hd__a21bo_1
XTAP_TAPCELL_ROW_15_192 VGND VPWR sky130_fd_sc_hd__tapvpwrvgnd_1
XTAP_TAPCELL_ROW_7_149 VGND VPWR sky130_fd_sc_hd__tapvpwrvgnd_1
XFILLER_43_259 VPWR VGND VPWR VGND sky130_ef_sc_hd__decap_12
XFILLER_51_281 VPWR VGND VPWR VGND sky130_ef_sc_hd__decap_12
XFILLER_11_167 VGND VGND VPWR VPWR sky130_fd_sc_hd__fill_1
XTAP_TAPCELL_ROW_29_273 VGND VPWR sky130_fd_sc_hd__tapvpwrvgnd_1
X_1910_ net140 _0996_ VGND VGND VPWR VPWR _0997_ sky130_fd_sc_hd__nor2_1
XFILLER_19_267 VPWR VGND VPWR VGND sky130_ef_sc_hd__decap_12
X_1772_ _0850_ _0851_ _0852_ VGND VGND VPWR VPWR _0854_ sky130_fd_sc_hd__nand3_1
X_1841_ _0893_ _0924_ VGND VGND VPWR VPWR _0925_ sky130_fd_sc_hd__xor2_1
XFILLER_8_43 VGND VGND VPWR VPWR sky130_fd_sc_hd__fill_1
XFILLER_8_76 VGND VGND VPWR VPWR sky130_fd_sc_hd__fill_1
X_1137_ _0233_ _0234_ _0235_ VGND VGND VPWR VPWR _0236_ sky130_fd_sc_hd__nand3_1
X_1206_ _0301_ _0302_ VGND VGND VPWR VPWR _0303_ sky130_fd_sc_hd__nor2_1
XFILLER_33_281 VGND VGND VPWR VPWR sky130_fd_sc_hd__decap_3
X_1068_ net114 net101 _0165_ _0167_ VGND VGND VPWR VPWR _0169_ sky130_fd_sc_hd__nand4_1
XFILLER_48_307 VGND VGND VPWR VPWR sky130_fd_sc_hd__fill_1
XTAP_TAPCELL_ROW_3_130 VGND VPWR sky130_fd_sc_hd__tapvpwrvgnd_1
XFILLER_17_41 VGND VGND VPWR VPWR sky130_fd_sc_hd__fill_2
XFILLER_17_96 VPWR VGND VPWR VGND sky130_ef_sc_hd__decap_12
XTAP_TAPCELL_ROW_26_254 VGND VPWR sky130_fd_sc_hd__tapvpwrvgnd_1
XTAP_TAPCELL_ROW_49_379 VGND VPWR sky130_fd_sc_hd__tapvpwrvgnd_1
X_2040_ clknet_2_2__leaf_clk _0031_ VGND VGND VPWR VPWR net41 sky130_fd_sc_hd__dfxtp_1
XFILLER_30_262 VPWR VGND VPWR VGND sky130_ef_sc_hd__decap_12
XFILLER_15_281 VPWR VGND VPWR VGND sky130_ef_sc_hd__decap_12
X_1824_ _0872_ _0874_ _0905_ _0906_ VGND VGND VPWR VPWR _0908_ sky130_fd_sc_hd__o211a_1
X_1686_ _0677_ _0649_ _0707_ _0739_ VGND VGND VPWR VPWR _0771_ sky130_fd_sc_hd__and4bb_1
X_1755_ net200 net85 _0837_ net89 VGND VGND VPWR VPWR _0024_ sky130_fd_sc_hd__o211a_1
XFILLER_30_295 VGND VGND VPWR VPWR sky130_fd_sc_hd__decap_8
XPHY_EDGE_ROW_29_Left_81 VGND VGND VPWR VPWR sky130_fd_sc_hd__decap_3
XPHY_EDGE_ROW_13_Left_65 VGND VGND VPWR VPWR sky130_fd_sc_hd__decap_3
XTAP_TAPCELL_ROW_0_111 VGND VPWR sky130_fd_sc_hd__tapvpwrvgnd_1
XFILLER_0_166 VGND VGND VPWR VPWR sky130_fd_sc_hd__fill_2
XFILLER_44_83 VGND VGND VPWR VPWR sky130_fd_sc_hd__fill_1
X_1540_ _0627_ _0628_ _0590_ _0592_ VGND VGND VPWR VPWR _0629_ sky130_fd_sc_hd__a211o_1
XFILLER_8_222 VGND VGND VPWR VPWR sky130_fd_sc_hd__fill_1
XFILLER_8_277 VPWR VGND VPWR VGND sky130_ef_sc_hd__decap_12
X_1471_ _0523_ _0525_ _0559_ _0560_ VGND VGND VPWR VPWR _0562_ sky130_fd_sc_hd__o211a_1
XFILLER_10_3 VGND VGND VPWR VPWR sky130_fd_sc_hd__fill_1
XTAP_TAPCELL_ROW_45_360 VGND VPWR sky130_fd_sc_hd__tapvpwrvgnd_1
XTAP_TAPCELL_ROW_37_316 VGND VPWR sky130_fd_sc_hd__tapvpwrvgnd_1
X_2023_ clknet_2_2__leaf_clk _0014_ VGND VGND VPWR VPWR net23 sky130_fd_sc_hd__dfxtp_1
X_1807_ net56 _0889_ VGND VGND VPWR VPWR _0891_ sky130_fd_sc_hd__xnor2_1
XFILLER_49_39 VPWR VGND VPWR VGND sky130_ef_sc_hd__decap_12
X_1738_ _0817_ _0818_ _0819_ VGND VGND VPWR VPWR _0821_ sky130_fd_sc_hd__nand3_1
X_1669_ _0751_ _0752_ _0753_ VGND VGND VPWR VPWR _0754_ sky130_fd_sc_hd__a21oi_1
XTAP_TAPCELL_ROW_51_396 VGND VPWR sky130_fd_sc_hd__tapvpwrvgnd_1
XFILLER_30_41 VPWR VGND VPWR VGND sky130_ef_sc_hd__decap_12
XFILLER_5_269 VGND VGND VPWR VPWR sky130_fd_sc_hd__decap_8
XFILLER_5_225 VGND VGND VPWR VPWR sky130_fd_sc_hd__decap_4
XFILLER_44_162 VGND VGND VPWR VPWR sky130_fd_sc_hd__decap_8
XFILLER_44_195 VGND VGND VPWR VPWR sky130_fd_sc_hd__fill_1
XTAP_TAPCELL_ROW_42_341 VGND VPWR sky130_fd_sc_hd__tapvpwrvgnd_1
X_1454_ _0544_ _0545_ VGND VGND VPWR VPWR _0546_ sky130_fd_sc_hd__nand2_1
X_1523_ _0576_ _0611_ _0612_ VGND VGND VPWR VPWR _0613_ sky130_fd_sc_hd__and3_1
X_1385_ _0468_ _0477_ VGND VGND VPWR VPWR _0478_ sky130_fd_sc_hd__nand2b_1
XFILLER_35_19 VGND VGND VPWR VPWR sky130_fd_sc_hd__decap_6
X_2006_ net44 net84 VGND VGND VPWR VPWR _0128_ sky130_fd_sc_hd__or2_1
XFILLER_51_29 VPWR VGND VPWR VGND sky130_ef_sc_hd__decap_12
XFILLER_18_118 VGND VGND VPWR VPWR sky130_fd_sc_hd__fill_1
XFILLER_41_165 VGND VGND VPWR VPWR sky130_fd_sc_hd__decap_3
XFILLER_41_84 VGND VGND VPWR VPWR sky130_fd_sc_hd__decap_8
XFILLER_49_254 VPWR VGND VPWR VGND sky130_ef_sc_hd__decap_12
XFILLER_1_261 VPWR VGND VPWR VGND sky130_ef_sc_hd__decap_12
X_1170_ _0266_ _0267_ VGND VGND VPWR VPWR _0268_ sky130_fd_sc_hd__nand2_1
X_1506_ _0556_ _0558_ _0593_ _0594_ VGND VGND VPWR VPWR _0596_ sky130_fd_sc_hd__o211a_1
X_1437_ _0480_ _0482_ _0526_ _0527_ VGND VGND VPWR VPWR _0529_ sky130_fd_sc_hd__o211a_1
XFILLER_46_29 VPWR VGND VPWR VGND sky130_ef_sc_hd__decap_12
X_1368_ _0461_ VGND VGND VPWR VPWR _0462_ sky130_fd_sc_hd__inv_2
X_1299_ net71 _0392_ _0393_ VGND VGND VPWR VPWR _0394_ sky130_fd_sc_hd__nor3_1
XFILLER_23_165 VGND VGND VPWR VPWR sky130_fd_sc_hd__decap_3
XFILLER_23_198 VGND VGND VPWR VPWR sky130_fd_sc_hd__decap_8
XFILLER_46_213 VPWR VGND VPWR VGND sky130_ef_sc_hd__decap_12
XFILLER_36_73 VGND VGND VPWR VPWR sky130_fd_sc_hd__fill_1
XPHY_EDGE_ROW_1_Left_53 VGND VGND VPWR VPWR sky130_fd_sc_hd__decap_3
Xinput15 weight[3] VGND VGND VPWR VPWR net15 sky130_fd_sc_hd__dlymetal6s2s_1
XFILLER_42_6 VGND VGND VPWR VPWR sky130_fd_sc_hd__decap_4
X_1153_ net102 net100 net110 net108 VGND VGND VPWR VPWR _0251_ sky130_fd_sc_hd__and4_1
X_1222_ _0315_ _0316_ _0317_ VGND VGND VPWR VPWR _0319_ sky130_fd_sc_hd__a21o_1
X_1084_ net78 _0182_ _0183_ _0184_ net86 VGND VGND VPWR VPWR _0006_ sky130_fd_sc_hd__o311a_1
XTAP_TAPCELL_ROW_15_193 VGND VPWR sky130_fd_sc_hd__tapvpwrvgnd_1
XFILLER_20_135 VGND VGND VPWR VPWR sky130_fd_sc_hd__decap_4
X_1986_ _0105_ _0106_ VGND VGND VPWR VPWR _0107_ sky130_fd_sc_hd__nand2b_1
XPHY_EDGE_ROW_43_Left_95 VGND VGND VPWR VPWR sky130_fd_sc_hd__decap_3
XFILLER_51_293 VPWR VGND VPWR VGND sky130_ef_sc_hd__decap_12
XFILLER_19_279 VGND VGND VPWR VPWR sky130_fd_sc_hd__fill_1
X_1840_ _0922_ _0923_ VGND VGND VPWR VPWR _0924_ sky130_fd_sc_hd__nor2_1
XFILLER_42_282 VGND VGND VPWR VPWR sky130_fd_sc_hd__fill_1
XFILLER_8_22 VGND VGND VPWR VPWR sky130_fd_sc_hd__decap_6
X_1771_ _0850_ _0851_ _0852_ VGND VGND VPWR VPWR _0853_ sky130_fd_sc_hd__a21o_1
X_1136_ _0192_ _0197_ _0191_ VGND VGND VPWR VPWR _0235_ sky130_fd_sc_hd__a21bo_1
X_1067_ net114 net101 _0165_ _0167_ VGND VGND VPWR VPWR _0168_ sky130_fd_sc_hd__and4_1
X_1205_ net112 net97 net98 net15 VGND VGND VPWR VPWR _0302_ sky130_fd_sc_hd__a22oi_1
XFILLER_18_290 VPWR VGND VPWR VGND sky130_ef_sc_hd__decap_12
XFILLER_25_249 VGND VGND VPWR VPWR sky130_fd_sc_hd__fill_1
X_1969_ _0262_ _0088_ VGND VGND VPWR VPWR _0089_ sky130_fd_sc_hd__xnor2_1
XFILLER_33_41 VGND VGND VPWR VPWR sky130_fd_sc_hd__fill_2
XTAP_TAPCELL_ROW_26_255 VGND VPWR sky130_fd_sc_hd__tapvpwrvgnd_1
XFILLER_16_249 VGND VGND VPWR VPWR sky130_fd_sc_hd__decap_3
X_1823_ _0905_ _0906_ _0872_ _0874_ VGND VGND VPWR VPWR _0907_ sky130_fd_sc_hd__a211oi_1
XFILLER_15_293 VPWR VGND VPWR VGND sky130_ef_sc_hd__decap_12
X_1754_ _0836_ _0835_ net80 VGND VGND VPWR VPWR _0837_ sky130_fd_sc_hd__a21o_1
X_1685_ _0707_ _0739_ _0708_ _0769_ _0738_ VGND VGND VPWR VPWR _0770_ sky130_fd_sc_hd__a311o_1
XTAP_TAPCELL_ROW_0_112 VGND VPWR sky130_fd_sc_hd__tapvpwrvgnd_1
X_1119_ _0213_ _0215_ _0216_ VGND VGND VPWR VPWR _0218_ sky130_fd_sc_hd__and3_1
XTAP_TAPCELL_ROW_23_236 VGND VPWR sky130_fd_sc_hd__tapvpwrvgnd_1
XTAP_TAPCELL_ROW_31_280 VGND VPWR sky130_fd_sc_hd__tapvpwrvgnd_1
XPHY_EDGE_ROW_17_Right_17 VGND VGND VPWR VPWR sky130_fd_sc_hd__decap_3
XPHY_EDGE_ROW_26_Right_26 VGND VGND VPWR VPWR sky130_fd_sc_hd__decap_3
XFILLER_48_127 VPWR VGND VPWR VGND sky130_ef_sc_hd__decap_12
XFILLER_44_73 VGND VGND VPWR VPWR sky130_fd_sc_hd__fill_2
XPHY_EDGE_ROW_35_Right_35 VGND VGND VPWR VPWR sky130_fd_sc_hd__decap_3
X_1470_ _0560_ _0559_ _0523_ _0525_ VGND VGND VPWR VPWR _0561_ sky130_fd_sc_hd__a211o_1
XPHY_EDGE_ROW_30_Left_82 VGND VGND VPWR VPWR sky130_fd_sc_hd__decap_3
XFILLER_5_89 VPWR VGND VPWR VGND sky130_ef_sc_hd__decap_12
XFILLER_5_45 VGND VGND VPWR VPWR sky130_fd_sc_hd__decap_8
XFILLER_8_289 VPWR VGND VPWR VGND sky130_ef_sc_hd__decap_12
XPHY_EDGE_ROW_44_Right_44 VGND VGND VPWR VPWR sky130_fd_sc_hd__decap_3
XFILLER_39_149 VGND VGND VPWR VPWR sky130_fd_sc_hd__decap_4
XTAP_TAPCELL_ROW_45_361 VGND VPWR sky130_fd_sc_hd__tapvpwrvgnd_1
XTAP_TAPCELL_ROW_37_317 VGND VPWR sky130_fd_sc_hd__tapvpwrvgnd_1
X_2022_ clknet_2_2__leaf_clk _0013_ VGND VGND VPWR VPWR net22 sky130_fd_sc_hd__dfxtp_1
X_1806_ _0887_ _0888_ VGND VGND VPWR VPWR _0889_ sky130_fd_sc_hd__nor2_1
X_1737_ _0817_ _0818_ _0819_ VGND VGND VPWR VPWR _0820_ sky130_fd_sc_hd__a21o_1
X_1668_ net66 _0719_ _0720_ VGND VGND VPWR VPWR _0753_ sky130_fd_sc_hd__a21o_1
X_1599_ _0684_ _0685_ _0652_ _0654_ VGND VGND VPWR VPWR _0686_ sky130_fd_sc_hd__a211o_1
XTAP_TAPCELL_ROW_51_397 VGND VPWR sky130_fd_sc_hd__tapvpwrvgnd_1
XFILLER_14_54 VGND VGND VPWR VPWR sky130_fd_sc_hd__fill_1
XFILLER_14_76 VGND VGND VPWR VPWR sky130_fd_sc_hd__fill_1
XFILLER_30_53 VGND VGND VPWR VPWR sky130_fd_sc_hd__decap_4
XFILLER_44_141 VGND VGND VPWR VPWR sky130_fd_sc_hd__decap_8
XTAP_TAPCELL_ROW_42_342 VGND VPWR sky130_fd_sc_hd__tapvpwrvgnd_1
X_1522_ _0608_ _0609_ _0610_ VGND VGND VPWR VPWR _0612_ sky130_fd_sc_hd__o21ai_1
X_1453_ _0502_ _0542_ _0543_ VGND VGND VPWR VPWR _0545_ sky130_fd_sc_hd__nand3_1
X_2005_ _0126_ _0114_ VGND VGND VPWR VPWR _0127_ sky130_fd_sc_hd__xnor2_1
X_1384_ _0470_ _0475_ VGND VGND VPWR VPWR _0477_ sky130_fd_sc_hd__xnor2_1
XFILLER_35_196 VPWR VGND VPWR VGND sky130_ef_sc_hd__decap_12
XFILLER_35_185 VGND VGND VPWR VPWR sky130_fd_sc_hd__decap_4
XFILLER_41_111 VGND VGND VPWR VPWR sky130_fd_sc_hd__fill_1
XFILLER_26_141 VGND VGND VPWR VPWR sky130_fd_sc_hd__decap_3
XFILLER_41_188 VGND VGND VPWR VPWR sky130_fd_sc_hd__fill_1
XFILLER_49_266 VPWR VGND VPWR VGND sky130_ef_sc_hd__decap_12
XFILLER_49_211 VGND VGND VPWR VPWR sky130_fd_sc_hd__decap_3
XFILLER_2_79 VGND VGND VPWR VPWR sky130_fd_sc_hd__decap_4
XFILLER_1_273 VGND VGND VPWR VPWR sky130_fd_sc_hd__decap_6
X_1505_ _0594_ _0593_ _0556_ _0558_ VGND VGND VPWR VPWR _0595_ sky130_fd_sc_hd__a211o_1
X_1436_ _0526_ _0527_ _0480_ _0482_ VGND VGND VPWR VPWR _0528_ sky130_fd_sc_hd__a211o_1
X_1367_ _0412_ _0413_ _0457_ _0458_ VGND VGND VPWR VPWR _0461_ sky130_fd_sc_hd__o22a_1
X_1298_ net118 net169 net21 VGND VGND VPWR VPWR _0393_ sky130_fd_sc_hd__a21oi_1
XFILLER_23_100 VGND VGND VPWR VPWR sky130_fd_sc_hd__decap_6
XFILLER_23_111 VGND VGND VPWR VPWR sky130_fd_sc_hd__fill_1
XFILLER_23_155 VGND VGND VPWR VPWR sky130_fd_sc_hd__fill_2
XFILLER_23_177 VGND VGND VPWR VPWR sky130_fd_sc_hd__decap_3
XFILLER_46_247 VGND VGND VPWR VPWR sky130_fd_sc_hd__decap_4
XFILLER_46_236 VGND VGND VPWR VPWR sky130_fd_sc_hd__fill_1
XFILLER_46_225 VGND VGND VPWR VPWR sky130_fd_sc_hd__decap_4
XFILLER_36_85 VGND VGND VPWR VPWR sky130_fd_sc_hd__fill_2
XFILLER_36_41 VGND VGND VPWR VPWR sky130_fd_sc_hd__decap_8
XFILLER_14_111 VGND VGND VPWR VPWR sky130_fd_sc_hd__decap_8
XFILLER_14_133 VGND VGND VPWR VPWR sky130_fd_sc_hd__decap_6
Xinput16 weight[4] VGND VGND VPWR VPWR net16 sky130_fd_sc_hd__clkbuf_2
X_1221_ _0315_ _0316_ _0317_ VGND VGND VPWR VPWR _0318_ sky130_fd_sc_hd__nand3_2
X_1152_ net102 net110 _0223_ _0222_ VGND VGND VPWR VPWR _0250_ sky130_fd_sc_hd__a31o_1
X_1083_ net46 net82 VGND VGND VPWR VPWR _0184_ sky130_fd_sc_hd__or2_1
XTAP_TAPCELL_ROW_15_194 VGND VPWR sky130_fd_sc_hd__tapvpwrvgnd_1
XFILLER_20_169 VGND VGND VPWR VPWR sky130_fd_sc_hd__fill_1
X_1985_ _0103_ _0104_ _0081_ VGND VGND VPWR VPWR _0106_ sky130_fd_sc_hd__a21o_1
XFILLER_28_247 VGND VGND VPWR VPWR sky130_fd_sc_hd__fill_1
X_1419_ net23 net84 VGND VGND VPWR VPWR _0512_ sky130_fd_sc_hd__or2_1
XFILLER_51_250 VGND VGND VPWR VPWR sky130_fd_sc_hd__fill_2
XFILLER_11_169 VPWR VGND VPWR VGND sky130_ef_sc_hd__decap_12
XFILLER_22_76 VGND VGND VPWR VPWR sky130_fd_sc_hd__fill_1
XFILLER_0_3 VPWR VGND VPWR VGND sky130_ef_sc_hd__decap_12
XFILLER_19_236 VGND VGND VPWR VPWR sky130_fd_sc_hd__decap_4
X_1770_ net59 _0815_ _0816_ VGND VGND VPWR VPWR _0852_ sky130_fd_sc_hd__o21bai_1
XFILLER_8_56 VGND VGND VPWR VPWR sky130_fd_sc_hd__fill_1
XTAP_TAPCELL_ROW_12_175 VGND VPWR sky130_fd_sc_hd__tapvpwrvgnd_1
XFILLER_33_3 VGND VGND VPWR VPWR sky130_fd_sc_hd__decap_4
X_1204_ net112 net111 net97 net98 VGND VGND VPWR VPWR _0301_ sky130_fd_sc_hd__and4_1
X_1135_ _0231_ _0232_ _0225_ VGND VGND VPWR VPWR _0234_ sky130_fd_sc_hd__a21o_1
X_1066_ net46 net116 net99 VGND VGND VPWR VPWR _0167_ sky130_fd_sc_hd__nand3_1
X_1899_ _0950_ _0957_ _0985_ VGND VGND VPWR VPWR _0986_ sky130_fd_sc_hd__a21oi_1
X_1968_ net43 net70 VGND VGND VPWR VPWR _0088_ sky130_fd_sc_hd__xor2_1
XFILLER_0_305 VGND VGND VPWR VPWR sky130_fd_sc_hd__decap_3
XTAP_TAPCELL_ROW_26_256 VGND VPWR sky130_fd_sc_hd__tapvpwrvgnd_1
X_1822_ _0903_ _0904_ net76 VGND VGND VPWR VPWR _0906_ sky130_fd_sc_hd__o21ai_1
X_1753_ _0834_ _0829_ VGND VGND VPWR VPWR _0836_ sky130_fd_sc_hd__or2_4
XFILLER_30_253 VGND VGND VPWR VPWR sky130_fd_sc_hd__decap_3
X_1684_ _0703_ _0737_ _0705_ VGND VGND VPWR VPWR _0769_ sky130_fd_sc_hd__a21oi_1
XTAP_TAPCELL_ROW_0_113 VGND VPWR sky130_fd_sc_hd__tapvpwrvgnd_1
X_1118_ _0215_ _0216_ VGND VGND VPWR VPWR _0217_ sky130_fd_sc_hd__nand2_1
X_1049_ _0145_ _0150_ VGND VGND VPWR VPWR _0151_ sky130_fd_sc_hd__nand2_1
XFILLER_21_220 VGND VGND VPWR VPWR sky130_fd_sc_hd__decap_4
XFILLER_21_242 VGND VGND VPWR VPWR sky130_fd_sc_hd__decap_3
XTAP_TAPCELL_ROW_23_237 VGND VPWR sky130_fd_sc_hd__tapvpwrvgnd_1
XTAP_TAPCELL_ROW_31_281 VGND VPWR sky130_fd_sc_hd__tapvpwrvgnd_1
XFILLER_21_286 VGND VGND VPWR VPWR sky130_fd_sc_hd__decap_6
XFILLER_48_139 VGND VGND VPWR VPWR sky130_fd_sc_hd__fill_1
XFILLER_0_113 VGND VGND VPWR VPWR sky130_fd_sc_hd__decap_3
XFILLER_28_53 VGND VGND VPWR VPWR sky130_fd_sc_hd__decap_4
XFILLER_44_85 VGND VGND VPWR VPWR sky130_fd_sc_hd__decap_8
XFILLER_12_253 VPWR VGND VPWR VGND sky130_ef_sc_hd__decap_12
XFILLER_39_128 VGND VGND VPWR VPWR sky130_fd_sc_hd__decap_3
X_2021_ clknet_2_2__leaf_clk _0012_ VGND VGND VPWR VPWR net21 sky130_fd_sc_hd__dfxtp_1
X_1736_ net60 _0787_ _0788_ VGND VGND VPWR VPWR _0819_ sky130_fd_sc_hd__o21bai_1
X_1805_ _0885_ _0886_ VGND VGND VPWR VPWR _0888_ sky130_fd_sc_hd__and2_1
X_1598_ _0681_ _0682_ net73 VGND VGND VPWR VPWR _0685_ sky130_fd_sc_hd__o21ai_1
X_1667_ _0748_ _0750_ net66 VGND VGND VPWR VPWR _0752_ sky130_fd_sc_hd__a21o_1
XTAP_TAPCELL_ROW_51_398 VGND VPWR sky130_fd_sc_hd__tapvpwrvgnd_1
XFILLER_14_99 VPWR VGND VPWR VGND sky130_ef_sc_hd__decap_12
XFILLER_30_98 VGND VGND VPWR VPWR sky130_fd_sc_hd__fill_2
XFILLER_39_63 VGND VGND VPWR VPWR sky130_fd_sc_hd__fill_1
XFILLER_39_52 VGND VGND VPWR VPWR sky130_fd_sc_hd__decap_4
XTAP_TAPCELL_ROW_42_343 VGND VPWR sky130_fd_sc_hd__tapvpwrvgnd_1
XFILLER_29_194 VPWR VGND VPWR VGND sky130_ef_sc_hd__decap_12
X_1521_ _0610_ _0609_ _0608_ VGND VGND VPWR VPWR _0611_ sky130_fd_sc_hd__or3_4
X_1383_ _0469_ _0475_ VGND VGND VPWR VPWR _0476_ sky130_fd_sc_hd__nand2_1
X_1452_ _0542_ _0543_ _0502_ VGND VGND VPWR VPWR _0544_ sky130_fd_sc_hd__a21o_1
X_2004_ _0103_ _0125_ VGND VGND VPWR VPWR _0126_ sky130_fd_sc_hd__xnor2_1
X_1719_ _0767_ _0773_ _0801_ net78 VGND VGND VPWR VPWR _0803_ sky130_fd_sc_hd__a31o_1
Xrebuffer50 _0598_ VGND VGND VPWR VPWR net175 sky130_fd_sc_hd__buf_1
XFILLER_26_197 VGND VGND VPWR VPWR sky130_fd_sc_hd__decap_8
XFILLER_26_175 VGND VGND VPWR VPWR sky130_fd_sc_hd__fill_1
XFILLER_25_54 VGND VGND VPWR VPWR sky130_fd_sc_hd__fill_2
XFILLER_25_98 VGND VGND VPWR VPWR sky130_fd_sc_hd__fill_1
XFILLER_49_223 VGND VGND VPWR VPWR sky130_fd_sc_hd__fill_1
XFILLER_49_278 VGND VGND VPWR VPWR sky130_fd_sc_hd__fill_2
XFILLER_2_47 VGND VGND VPWR VPWR sky130_fd_sc_hd__decap_6
XFILLER_2_36 VGND VGND VPWR VPWR sky130_fd_sc_hd__decap_4
XFILLER_32_178 VPWR VGND VPWR VGND sky130_ef_sc_hd__decap_12
X_1504_ _0590_ _0591_ net177 VGND VGND VPWR VPWR _0594_ sky130_fd_sc_hd__o21ai_1
X_1435_ _0523_ _0524_ net72 VGND VGND VPWR VPWR _0527_ sky130_fd_sc_hd__o21ai_1
X_1366_ _0459_ VGND VGND VPWR VPWR _0460_ sky130_fd_sc_hd__inv_2
X_1297_ net21 net118 net90 VGND VGND VPWR VPWR _0392_ sky130_fd_sc_hd__and3_4
XFILLER_11_45 VGND VGND VPWR VPWR sky130_fd_sc_hd__fill_1
XFILLER_14_167 VGND VGND VPWR VPWR sky130_fd_sc_hd__decap_6
Xinput17 weight[5] VGND VGND VPWR VPWR net17 sky130_fd_sc_hd__buf_1
XFILLER_28_6 VPWR VGND VPWR VGND sky130_ef_sc_hd__decap_12
X_1151_ _0248_ VGND VGND VPWR VPWR _0249_ sky130_fd_sc_hd__inv_2
XTAP_TAPCELL_ROW_9_160 VGND VPWR sky130_fd_sc_hd__tapvpwrvgnd_1
X_1220_ _0261_ _0269_ _0268_ VGND VGND VPWR VPWR _0317_ sky130_fd_sc_hd__a21bo_1
XFILLER_45_281 VPWR VGND VPWR VGND sky130_ef_sc_hd__decap_12
XFILLER_45_270 VGND VGND VPWR VPWR sky130_fd_sc_hd__decap_8
X_1082_ _0179_ _0180_ VGND VGND VPWR VPWR _0183_ sky130_fd_sc_hd__and2_1
XTAP_TAPCELL_ROW_15_195 VGND VPWR sky130_fd_sc_hd__tapvpwrvgnd_1
X_1984_ _0081_ _0103_ _0104_ VGND VGND VPWR VPWR _0105_ sky130_fd_sc_hd__and3_1
XFILLER_28_259 VGND VGND VPWR VPWR sky130_fd_sc_hd__fill_2
X_1418_ _0506_ _0509_ VGND VGND VPWR VPWR _0511_ sky130_fd_sc_hd__xor2_1
X_1349_ _0392_ _0394_ _0440_ _0441_ VGND VGND VPWR VPWR _0443_ sky130_fd_sc_hd__o211ai_1
XFILLER_43_229 VGND VGND VPWR VPWR sky130_fd_sc_hd__fill_1
XFILLER_36_281 VGND VGND VPWR VPWR sky130_fd_sc_hd__decap_3
XFILLER_27_281 VPWR VGND VPWR VGND sky130_ef_sc_hd__decap_12
XTAP_TAPCELL_ROW_12_176 VGND VPWR sky130_fd_sc_hd__tapvpwrvgnd_1
XFILLER_6_141 VGND VGND VPWR VPWR sky130_fd_sc_hd__decap_4
XFILLER_6_152 VGND VGND VPWR VPWR sky130_fd_sc_hd__fill_1
XFILLER_6_163 VPWR VGND VPWR VGND sky130_ef_sc_hd__decap_12
X_1134_ _0225_ _0231_ _0232_ VGND VGND VPWR VPWR _0233_ sky130_fd_sc_hd__nand3_1
X_1203_ _0290_ _0298_ VGND VGND VPWR VPWR _0300_ sky130_fd_sc_hd__xor2_1
X_1065_ net46 net116 net99 VGND VGND VPWR VPWR _0166_ sky130_fd_sc_hd__and3_1
XFILLER_18_281 VGND VGND VPWR VPWR sky130_fd_sc_hd__fill_2
X_1898_ _0982_ _0984_ VGND VGND VPWR VPWR _0985_ sky130_fd_sc_hd__nor2_1
X_1967_ net41 net84 _0086_ _0085_ net88 VGND VGND VPWR VPWR _0031_ sky130_fd_sc_hd__o221a_1
XFILLER_17_55 VGND VGND VPWR VPWR sky130_fd_sc_hd__fill_1
XTAP_TAPCELL_ROW_26_257 VGND VPWR sky130_fd_sc_hd__tapvpwrvgnd_1
X_1683_ net164 _0766_ VGND VGND VPWR VPWR _0768_ sky130_fd_sc_hd__xnor2_2
X_1821_ net76 _0903_ _0904_ VGND VGND VPWR VPWR _0905_ sky130_fd_sc_hd__or3_1
X_1752_ _0829_ _0834_ VGND VGND VPWR VPWR _0835_ sky130_fd_sc_hd__nand2_4
X_1117_ net104 net108 net106 net124 VGND VGND VPWR VPWR _0216_ sky130_fd_sc_hd__a22o_1
XTAP_TAPCELL_ROW_0_114 VGND VPWR sky130_fd_sc_hd__tapvpwrvgnd_1
XPHY_EDGE_ROW_3_Right_3 VGND VGND VPWR VPWR sky130_fd_sc_hd__decap_3
X_1048_ _0149_ VGND VGND VPWR VPWR _0150_ sky130_fd_sc_hd__inv_2
XTAP_TAPCELL_ROW_23_238 VGND VPWR sky130_fd_sc_hd__tapvpwrvgnd_1
XTAP_TAPCELL_ROW_31_282 VGND VPWR sky130_fd_sc_hd__tapvpwrvgnd_1
XFILLER_21_298 VGND VGND VPWR VPWR sky130_fd_sc_hd__decap_8
XFILLER_48_118 VGND VGND VPWR VPWR sky130_fd_sc_hd__decap_3
XFILLER_0_169 VPWR VGND VPWR VGND sky130_ef_sc_hd__decap_12
XFILLER_44_302 VGND VGND VPWR VPWR sky130_fd_sc_hd__decap_6
XFILLER_12_265 VPWR VGND VPWR VGND sky130_ef_sc_hd__decap_12
XFILLER_47_151 VGND VGND VPWR VPWR sky130_fd_sc_hd__decap_6
X_2020_ clknet_2_2__leaf_clk _0011_ VGND VGND VPWR VPWR net51 sky130_fd_sc_hd__dfxtp_1
XPHY_EDGE_ROW_17_Left_69 VGND VGND VPWR VPWR sky130_fd_sc_hd__decap_3
XTAP_TAPCELL_ROW_20_219 VGND VPWR sky130_fd_sc_hd__tapvpwrvgnd_1
X_1666_ _0749_ net148 _0748_ VGND VGND VPWR VPWR _0751_ sky130_fd_sc_hd__or3b_1
X_1735_ _0815_ _0816_ net59 VGND VGND VPWR VPWR _0818_ sky130_fd_sc_hd__o21ai_1
X_1804_ _0885_ _0886_ VGND VGND VPWR VPWR _0887_ sky130_fd_sc_hd__nor2_1
X_1597_ _0681_ net73 _0682_ VGND VGND VPWR VPWR _0684_ sky130_fd_sc_hd__or3_4
XFILLER_38_195 VGND VGND VPWR VPWR sky130_fd_sc_hd__fill_1
XTAP_TAPCELL_ROW_51_399 VGND VPWR sky130_fd_sc_hd__tapvpwrvgnd_1
XFILLER_39_20 VGND VGND VPWR VPWR sky130_fd_sc_hd__decap_4
XFILLER_44_121 VGND VGND VPWR VPWR sky130_fd_sc_hd__decap_3
XTAP_TAPCELL_ROW_42_344 VGND VPWR sky130_fd_sc_hd__tapvpwrvgnd_1
X_1520_ _0549_ _0573_ _0572_ VGND VGND VPWR VPWR _0610_ sky130_fd_sc_hd__a21boi_1
X_1451_ _0540_ _0541_ _0498_ _0500_ VGND VGND VPWR VPWR _0543_ sky130_fd_sc_hd__o211ai_1
X_1382_ _0473_ _0474_ VGND VGND VPWR VPWR _0475_ sky130_fd_sc_hd__xnor2_1
X_2003_ _0115_ _0124_ VGND VGND VPWR VPWR _0125_ sky130_fd_sc_hd__xnor2_1
X_1718_ _0767_ _0773_ _0801_ VGND VGND VPWR VPWR _0802_ sky130_fd_sc_hd__a21oi_1
X_1649_ _0733_ _0732_ _0734_ VGND VGND VPWR VPWR _0735_ sky130_fd_sc_hd__and3_1
XFILLER_2_209 VPWR VGND VPWR VGND sky130_ef_sc_hd__decap_12
XFILLER_26_110 VPWR VGND VPWR VGND sky130_ef_sc_hd__decap_12
XFILLER_41_113 VPWR VGND VPWR VGND sky130_ef_sc_hd__decap_12
Xrebuffer51 _0595_ VGND VGND VPWR VPWR net176 sky130_fd_sc_hd__buf_1
Xrebuffer40 net113 VGND VGND VPWR VPWR net165 sky130_fd_sc_hd__dlygate4sd1_1
XFILLER_26_154 VGND VGND VPWR VPWR sky130_fd_sc_hd__decap_6
XFILLER_41_65 VGND VGND VPWR VPWR sky130_fd_sc_hd__fill_1
XFILLER_2_15 VPWR VGND VPWR VGND sky130_ef_sc_hd__decap_12
XFILLER_17_165 VGND VGND VPWR VPWR sky130_fd_sc_hd__decap_3
X_1503_ _0590_ net74 _0591_ VGND VGND VPWR VPWR _0593_ sky130_fd_sc_hd__or3_4
X_1434_ net72 _0523_ _0524_ VGND VGND VPWR VPWR _0526_ sky130_fd_sc_hd__or3_1
X_1365_ _0412_ _0458_ _0457_ _0413_ VGND VGND VPWR VPWR _0459_ sky130_fd_sc_hd__nor4_4
X_1296_ net128 _0390_ VGND VGND VPWR VPWR _0391_ sky130_fd_sc_hd__xnor2_2
XFILLER_23_113 VPWR VGND VPWR VGND sky130_ef_sc_hd__decap_12
XFILLER_11_57 VGND VGND VPWR VPWR sky130_fd_sc_hd__fill_2
Xinput18 weight[6] VGND VGND VPWR VPWR net18 sky130_fd_sc_hd__buf_1
XFILLER_6_301 VGND VGND VPWR VPWR sky130_fd_sc_hd__decap_6
X_1150_ net124 _0868_ VGND VGND VPWR VPWR _0248_ sky130_fd_sc_hd__nor2_1
XTAP_TAPCELL_ROW_9_161 VGND VPWR sky130_fd_sc_hd__tapvpwrvgnd_1
XFILLER_45_293 VPWR VGND VPWR VGND sky130_ef_sc_hd__decap_12
XFILLER_37_249 VGND VGND VPWR VPWR sky130_fd_sc_hd__decap_4
X_1081_ _0179_ _0180_ VGND VGND VPWR VPWR _0182_ sky130_fd_sc_hd__nor2_1
XTAP_TAPCELL_ROW_15_196 VGND VPWR sky130_fd_sc_hd__tapvpwrvgnd_1
X_1983_ _0075_ _0078_ _0102_ VGND VGND VPWR VPWR _0104_ sky130_fd_sc_hd__or3_1
X_1417_ _0419_ _0507_ _0460_ _0508_ _0506_ VGND VGND VPWR VPWR _0510_ sky130_fd_sc_hd__a311o_4
XFILLER_28_205 VPWR VGND VPWR VGND sky130_ef_sc_hd__decap_12
X_1279_ _0373_ _0374_ VGND VGND VPWR VPWR _0375_ sky130_fd_sc_hd__nor2_1
X_1348_ _0392_ _0394_ _0440_ _0441_ VGND VGND VPWR VPWR _0442_ sky130_fd_sc_hd__o211a_1
XFILLER_11_149 VPWR VGND VPWR VGND sky130_ef_sc_hd__decap_12
XFILLER_22_12 VGND VGND VPWR VPWR sky130_fd_sc_hd__decap_3
XFILLER_22_23 VGND VGND VPWR VPWR sky130_fd_sc_hd__fill_2
XPHY_EDGE_ROW_5_Left_57 VGND VGND VPWR VPWR sky130_fd_sc_hd__decap_3
XFILLER_47_31 VPWR VGND VPWR VGND sky130_ef_sc_hd__decap_12
XTAP_TAPCELL_ROW_6_142 VGND VPWR sky130_fd_sc_hd__tapvpwrvgnd_1
XFILLER_27_293 VGND VGND VPWR VPWR sky130_fd_sc_hd__fill_1
XFILLER_6_120 VGND VGND VPWR VPWR sky130_fd_sc_hd__decap_4
XFILLER_8_36 VGND VGND VPWR VPWR sky130_fd_sc_hd__fill_1
XFILLER_10_193 VGND VGND VPWR VPWR sky130_fd_sc_hd__decap_3
XTAP_TAPCELL_ROW_12_177 VGND VPWR sky130_fd_sc_hd__tapvpwrvgnd_1
XFILLER_6_175 VPWR VGND VPWR VGND sky130_ef_sc_hd__decap_12
X_1202_ _0290_ _0298_ VGND VGND VPWR VPWR _0299_ sky130_fd_sc_hd__nand2_1
X_1133_ _0229_ _0230_ _0188_ _0189_ VGND VGND VPWR VPWR _0232_ sky130_fd_sc_hd__o211ai_2
X_1064_ net116 net99 net46 VGND VGND VPWR VPWR _0165_ sky130_fd_sc_hd__a21o_1
XFILLER_19_3 VGND VGND VPWR VPWR sky130_fd_sc_hd__fill_2
X_1966_ _0054_ _0044_ _0083_ net79 VGND VGND VPWR VPWR _0086_ sky130_fd_sc_hd__a31o_1
XPHY_EDGE_ROW_47_Left_99 VGND VGND VPWR VPWR sky130_fd_sc_hd__decap_3
X_1897_ _0947_ _0981_ VGND VGND VPWR VPWR _0984_ sky130_fd_sc_hd__and2_1
XFILLER_3_167 VGND VGND VPWR VPWR sky130_fd_sc_hd__fill_1
XFILLER_3_134 VPWR VGND VPWR VGND sky130_ef_sc_hd__decap_12
X_1820_ net121 net94 net37 VGND VGND VPWR VPWR _0904_ sky130_fd_sc_hd__a21oi_1
XFILLER_30_222 VGND VGND VPWR VPWR sky130_fd_sc_hd__fill_2
XTAP_TAPCELL_ROW_17_203 VGND VPWR sky130_fd_sc_hd__tapvpwrvgnd_1
X_1682_ _0764_ _0765_ _0735_ VGND VGND VPWR VPWR _0767_ sky130_fd_sc_hd__or3b_4
X_1751_ _0800_ _0833_ _0830_ VGND VGND VPWR VPWR _0834_ sky130_fd_sc_hd__or3_4
X_1116_ net104 net124 net108 net106 VGND VGND VPWR VPWR _0215_ sky130_fd_sc_hd__nand4_2
XTAP_TAPCELL_ROW_0_104 VGND VPWR sky130_fd_sc_hd__tapvpwrvgnd_1
X_1047_ _0146_ _0148_ VGND VGND VPWR VPWR _0149_ sky130_fd_sc_hd__nand2_1
XTAP_TAPCELL_ROW_31_283 VGND VPWR sky130_fd_sc_hd__tapvpwrvgnd_1
XTAP_TAPCELL_ROW_23_239 VGND VPWR sky130_fd_sc_hd__tapvpwrvgnd_1
X_1949_ _0066_ _0067_ VGND VGND VPWR VPWR _0068_ sky130_fd_sc_hd__nor2_1
XFILLER_0_148 VGND VGND VPWR VPWR sky130_fd_sc_hd__fill_2
XFILLER_12_277 VPWR VGND VPWR VGND sky130_ef_sc_hd__decap_12
XPHY_EDGE_ROW_8_Left_60 VGND VGND VPWR VPWR sky130_fd_sc_hd__decap_3
XPHY_EDGE_ROW_13_Right_13 VGND VGND VPWR VPWR sky130_fd_sc_hd__decap_3
X_1803_ _0849_ _0850_ VGND VGND VPWR VPWR _0886_ sky130_fd_sc_hd__nand2_1
XPHY_EDGE_ROW_22_Right_22 VGND VGND VPWR VPWR sky130_fd_sc_hd__decap_3
X_1665_ _0714_ _0716_ _0746_ _0747_ VGND VGND VPWR VPWR _0750_ sky130_fd_sc_hd__o211ai_1
X_1596_ net73 _0681_ _0682_ VGND VGND VPWR VPWR _0683_ sky130_fd_sc_hd__nor3_1
X_1734_ net59 _0815_ _0816_ VGND VGND VPWR VPWR _0817_ sky130_fd_sc_hd__or3_1
XFILLER_7_281 VPWR VGND VPWR VGND sky130_ef_sc_hd__decap_12
XPHY_EDGE_ROW_31_Right_31 VGND VGND VPWR VPWR sky130_fd_sc_hd__decap_3
XFILLER_14_24 VGND VGND VPWR VPWR sky130_fd_sc_hd__decap_4
XFILLER_14_35 VGND VGND VPWR VPWR sky130_fd_sc_hd__fill_1
XPHY_EDGE_ROW_40_Right_40 VGND VGND VPWR VPWR sky130_fd_sc_hd__decap_3
XFILLER_30_78 VGND VGND VPWR VPWR sky130_fd_sc_hd__decap_6
XPHY_EDGE_ROW_34_Left_86 VGND VGND VPWR VPWR sky130_fd_sc_hd__decap_3
XTAP_TAPCELL_ROW_42_345 VGND VPWR sky130_fd_sc_hd__tapvpwrvgnd_1
XFILLER_4_251 VGND VGND VPWR VPWR sky130_fd_sc_hd__fill_1
X_1450_ _0498_ _0500_ _0540_ _0541_ VGND VGND VPWR VPWR _0542_ sky130_fd_sc_hd__a211o_4
X_1381_ net6 _0868_ VGND VGND VPWR VPWR _0474_ sky130_fd_sc_hd__nor2_1
X_2002_ _0122_ _0123_ VGND VGND VPWR VPWR _0124_ sky130_fd_sc_hd__xnor2_1
XFILLER_50_158 VGND VGND VPWR VPWR sky130_fd_sc_hd__decap_3
X_1717_ _0799_ _0764_ VGND VGND VPWR VPWR _0801_ sky130_fd_sc_hd__xor2_2
X_1648_ net61 _0697_ _0698_ VGND VGND VPWR VPWR _0734_ sky130_fd_sc_hd__a21bo_1
X_1579_ net57 _0635_ _0636_ VGND VGND VPWR VPWR _0667_ sky130_fd_sc_hd__o21bai_1
XFILLER_6_91 VGND VGND VPWR VPWR sky130_fd_sc_hd__fill_1
Xrebuffer41 net165 VGND VGND VPWR VPWR net166 sky130_fd_sc_hd__dlymetal6s2s_1
XFILLER_26_122 VPWR VGND VPWR VGND sky130_ef_sc_hd__decap_12
XFILLER_41_125 VGND VGND VPWR VPWR sky130_fd_sc_hd__decap_8
XFILLER_41_99 VPWR VGND VPWR VGND sky130_ef_sc_hd__decap_12
XFILLER_41_44 VPWR VGND VPWR VGND sky130_ef_sc_hd__decap_12
XFILLER_49_203 VGND VGND VPWR VPWR sky130_fd_sc_hd__decap_8
XFILLER_2_27 VGND VGND VPWR VPWR sky130_fd_sc_hd__fill_1
XFILLER_17_155 VGND VGND VPWR VPWR sky130_fd_sc_hd__fill_2
XFILLER_49_3 VPWR VGND VPWR VGND sky130_ef_sc_hd__decap_12
X_1502_ net74 _0590_ _0591_ VGND VGND VPWR VPWR _0592_ sky130_fd_sc_hd__nor3_1
X_1433_ net72 _0523_ _0524_ VGND VGND VPWR VPWR _0525_ sky130_fd_sc_hd__nor3_1
X_1364_ _0455_ _0456_ _0408_ _0410_ VGND VGND VPWR VPWR _0458_ sky130_fd_sc_hd__o211a_1
X_1295_ net16 net96 VGND VGND VPWR VPWR _0390_ sky130_fd_sc_hd__nand2_1
XFILLER_23_125 VPWR VGND VPWR VGND sky130_ef_sc_hd__decap_12
XFILLER_23_147 VGND VGND VPWR VPWR sky130_fd_sc_hd__decap_8
XFILLER_23_169 VGND VGND VPWR VPWR sky130_fd_sc_hd__decap_8
Xinput19 weight[7] VGND VGND VPWR VPWR net19 sky130_fd_sc_hd__clkbuf_2
XTAP_TAPCELL_ROW_9_162 VGND VPWR sky130_fd_sc_hd__tapvpwrvgnd_1
X_1080_ _0179_ _0180_ VGND VGND VPWR VPWR _0181_ sky130_fd_sc_hd__nand2b_1
XFILLER_20_139 VGND VGND VPWR VPWR sky130_fd_sc_hd__fill_1
X_1982_ _0075_ _0078_ _0102_ VGND VGND VPWR VPWR _0103_ sky130_fd_sc_hd__o21ai_1
XPHY_EDGE_ROW_21_Left_73 VGND VGND VPWR VPWR sky130_fd_sc_hd__decap_3
X_1416_ _0419_ _0460_ _0507_ _0508_ VGND VGND VPWR VPWR _0509_ sky130_fd_sc_hd__a31o_1
X_1347_ _0437_ _0438_ net71 VGND VGND VPWR VPWR _0441_ sky130_fd_sc_hd__o21ai_1
XFILLER_43_209 VGND VGND VPWR VPWR sky130_fd_sc_hd__decap_4
XFILLER_36_294 VGND VGND VPWR VPWR sky130_fd_sc_hd__fill_2
XFILLER_28_217 VGND VGND VPWR VPWR sky130_fd_sc_hd__decap_8
X_1278_ _0284_ _0331_ _0330_ VGND VGND VPWR VPWR _0374_ sky130_fd_sc_hd__a21oi_1
XFILLER_51_253 VPWR VGND VPWR VGND sky130_ef_sc_hd__decap_12
XFILLER_3_305 VGND VGND VPWR VPWR sky130_fd_sc_hd__decap_4
XFILLER_47_43 VPWR VGND VPWR VGND sky130_ef_sc_hd__decap_12
XTAP_TAPCELL_ROW_6_143 VGND VPWR sky130_fd_sc_hd__tapvpwrvgnd_1
XFILLER_8_15 VGND VGND VPWR VPWR sky130_fd_sc_hd__fill_1
XFILLER_6_110 VGND VGND VPWR VPWR sky130_fd_sc_hd__decap_4
XTAP_TAPCELL_ROW_12_178 VGND VPWR sky130_fd_sc_hd__tapvpwrvgnd_1
X_1201_ _0291_ _0296_ VGND VGND VPWR VPWR _0298_ sky130_fd_sc_hd__xnor2_1
X_1063_ _0162_ _0163_ VGND VGND VPWR VPWR _0164_ sky130_fd_sc_hd__nor2_1
X_1132_ _0188_ _0189_ _0229_ _0230_ VGND VGND VPWR VPWR _0231_ sky130_fd_sc_hd__a211o_1
XFILLER_33_242 VGND VGND VPWR VPWR sky130_fd_sc_hd__fill_1
X_1965_ net159 _0044_ _0083_ VGND VGND VPWR VPWR _0085_ sky130_fd_sc_hd__a21oi_1
X_1896_ _0947_ _0981_ VGND VGND VPWR VPWR _0982_ sky130_fd_sc_hd__nor2_1
XFILLER_17_46 VGND VGND VPWR VPWR sky130_fd_sc_hd__fill_1
XFILLER_3_146 VGND VGND VPWR VPWR sky130_fd_sc_hd__decap_8
XFILLER_3_113 VPWR VGND VPWR VGND sky130_ef_sc_hd__decap_12
XTAP_TAPCELL_ROW_17_204 VGND VPWR sky130_fd_sc_hd__tapvpwrvgnd_1
X_1750_ _0831_ _0772_ VGND VGND VPWR VPWR _0833_ sky130_fd_sc_hd__nor2_1
X_1681_ _0764_ _0765_ VGND VGND VPWR VPWR _0766_ sky130_fd_sc_hd__or2_1
XTAP_TAPCELL_ROW_48_373 VGND VPWR sky130_fd_sc_hd__tapvpwrvgnd_1
XTAP_TAPCELL_ROW_0_105 VGND VPWR sky130_fd_sc_hd__tapvpwrvgnd_1
X_1115_ net104 net106 VGND VGND VPWR VPWR _0214_ sky130_fd_sc_hd__nand2_1
X_1046_ _0147_ VGND VGND VPWR VPWR _0148_ sky130_fd_sc_hd__inv_2
XTAP_TAPCELL_ROW_31_284 VGND VPWR sky130_fd_sc_hd__tapvpwrvgnd_1
X_1879_ _0960_ _0962_ net72 VGND VGND VPWR VPWR _0964_ sky130_fd_sc_hd__o21a_1
XFILLER_21_278 VGND VGND VPWR VPWR sky130_fd_sc_hd__fill_2
X_1948_ net68 _0065_ VGND VGND VPWR VPWR _0067_ sky130_fd_sc_hd__nor2_1
XFILLER_28_89 VPWR VGND VPWR VGND sky130_ef_sc_hd__decap_12
XFILLER_8_216 VGND VGND VPWR VPWR sky130_fd_sc_hd__decap_6
XFILLER_12_201 VPWR VGND VPWR VGND sky130_ef_sc_hd__decap_12
XFILLER_12_289 VPWR VGND VPWR VGND sky130_ef_sc_hd__decap_12
XFILLER_39_109 VGND VGND VPWR VPWR sky130_fd_sc_hd__decap_3
XFILLER_50_307 VGND VGND VPWR VPWR sky130_fd_sc_hd__fill_1
XFILLER_47_164 VGND VGND VPWR VPWR sky130_fd_sc_hd__decap_4
XFILLER_35_304 VGND VGND VPWR VPWR sky130_fd_sc_hd__decap_4
Xclkbuf_2_3__f_clk clknet_0_clk VGND VGND VPWR VPWR clknet_2_3__leaf_clk sky130_fd_sc_hd__clkbuf_16
X_1733_ _0812_ _0813_ _0814_ VGND VGND VPWR VPWR _0816_ sky130_fd_sc_hd__and3_1
X_1802_ _0588_ _0884_ VGND VGND VPWR VPWR _0885_ sky130_fd_sc_hd__xnor2_1
X_1664_ _0714_ _0716_ _0746_ _0747_ VGND VGND VPWR VPWR _0749_ sky130_fd_sc_hd__o211a_1
X_1595_ net120 net93 net29 VGND VGND VPWR VPWR _0682_ sky130_fd_sc_hd__a21oi_1
XFILLER_7_293 VPWR VGND VPWR VGND sky130_ef_sc_hd__decap_12
XFILLER_38_197 VGND VGND VPWR VPWR sky130_fd_sc_hd__decap_4
XFILLER_38_175 VGND VGND VPWR VPWR sky130_fd_sc_hd__fill_1
XTAP_TAPCELL_ROW_36_310 VGND VPWR sky130_fd_sc_hd__tapvpwrvgnd_1
X_1029_ net125 net172 _0131_ VGND VGND VPWR VPWR _0132_ sky130_fd_sc_hd__nand3_1
XFILLER_30_13 VPWR VGND VPWR VGND sky130_ef_sc_hd__decap_12
XFILLER_29_120 VGND VGND VPWR VPWR sky130_fd_sc_hd__decap_6
XFILLER_29_142 VGND VGND VPWR VPWR sky130_fd_sc_hd__fill_1
X_1380_ net96 _0471_ _0472_ VGND VGND VPWR VPWR _0473_ sky130_fd_sc_hd__a21bo_1
X_2001_ _0094_ _0095_ net59 VGND VGND VPWR VPWR _0123_ sky130_fd_sc_hd__mux2_1
XFILLER_35_189 VGND VGND VPWR VPWR sky130_fd_sc_hd__fill_1
X_1716_ _0764_ _0799_ VGND VGND VPWR VPWR _0800_ sky130_fd_sc_hd__and2_1
XFILLER_6_70 VPWR VGND VPWR VGND sky130_ef_sc_hd__decap_12
X_1647_ _0730_ _0731_ net61 VGND VGND VPWR VPWR _0733_ sky130_fd_sc_hd__a21o_1
X_1578_ _0663_ _0664_ net57 VGND VGND VPWR VPWR _0666_ sky130_fd_sc_hd__o21ai_1
XFILLER_14_307 VGND VGND VPWR VPWR sky130_fd_sc_hd__fill_1
Xrebuffer42 net113 VGND VGND VPWR VPWR net167 sky130_fd_sc_hd__clkbuf_1
Xrebuffer20 _0454_ VGND VGND VPWR VPWR net145 sky130_fd_sc_hd__buf_1
XFILLER_26_134 VGND VGND VPWR VPWR sky130_fd_sc_hd__decap_6
XFILLER_25_46 VGND VGND VPWR VPWR sky130_fd_sc_hd__decap_8
XFILLER_25_57 VGND VGND VPWR VPWR sky130_fd_sc_hd__fill_1
XFILLER_9_3 VPWR VGND VPWR VGND sky130_ef_sc_hd__decap_12
XFILLER_17_178 VPWR VGND VPWR VGND sky130_ef_sc_hd__decap_12
X_1501_ net120 net93 net26 VGND VGND VPWR VPWR _0591_ sky130_fd_sc_hd__a21oi_1
X_1432_ net119 net91 net24 VGND VGND VPWR VPWR _0524_ sky130_fd_sc_hd__a21oi_1
X_1363_ _0408_ _0410_ _0455_ _0456_ VGND VGND VPWR VPWR _0457_ sky130_fd_sc_hd__a211oi_2
X_1294_ _0346_ _0388_ VGND VGND VPWR VPWR _0389_ sky130_fd_sc_hd__and2b_2
XFILLER_23_137 VGND VGND VPWR VPWR sky130_fd_sc_hd__decap_4
XFILLER_11_37 VGND VGND VPWR VPWR sky130_fd_sc_hd__decap_8
XFILLER_39_281 VGND VGND VPWR VPWR sky130_fd_sc_hd__fill_2
XFILLER_14_126 VGND VGND VPWR VPWR sky130_fd_sc_hd__fill_2
XTAP_TAPCELL_ROW_9_163 VGND VPWR sky130_fd_sc_hd__tapvpwrvgnd_1
XFILLER_45_240 VGND VGND VPWR VPWR sky130_fd_sc_hd__decap_6
X_1981_ net56 _0101_ VGND VGND VPWR VPWR _0102_ sky130_fd_sc_hd__xnor2_1
XFILLER_9_185 VGND VGND VPWR VPWR sky130_fd_sc_hd__decap_8
X_1415_ _0370_ _0414_ _0460_ _0461_ VGND VGND VPWR VPWR _0508_ sky130_fd_sc_hd__a31o_1
X_1346_ net70 _0437_ _0438_ VGND VGND VPWR VPWR _0440_ sky130_fd_sc_hd__or3_4
XFILLER_36_251 VGND VGND VPWR VPWR sky130_fd_sc_hd__fill_1
X_1277_ _0372_ _0327_ VGND VGND VPWR VPWR _0373_ sky130_fd_sc_hd__xor2_4
XFILLER_51_265 VPWR VGND VPWR VGND sky130_ef_sc_hd__decap_12
Xfanout120 net123 VGND VGND VPWR VPWR net120 sky130_fd_sc_hd__buf_6
XFILLER_47_55 VGND VGND VPWR VPWR sky130_fd_sc_hd__fill_1
XTAP_TAPCELL_ROW_6_144 VGND VPWR sky130_fd_sc_hd__tapvpwrvgnd_1
XFILLER_19_207 VGND VGND VPWR VPWR sky130_fd_sc_hd__fill_1
XTAP_TAPCELL_ROW_12_179 VGND VPWR sky130_fd_sc_hd__tapvpwrvgnd_1
X_1200_ _0291_ _0296_ VGND VGND VPWR VPWR _0297_ sky130_fd_sc_hd__nand2b_1
X_1062_ net124 net110 _0160_ _0161_ VGND VGND VPWR VPWR _0163_ sky130_fd_sc_hd__o2bb2a_1
X_1131_ _0227_ _0228_ _0226_ VGND VGND VPWR VPWR _0230_ sky130_fd_sc_hd__o21a_1
XFILLER_18_251 VGND VGND VPWR VPWR sky130_fd_sc_hd__fill_1
X_1895_ _0978_ _0979_ VGND VGND VPWR VPWR _0981_ sky130_fd_sc_hd__xnor2_1
X_1964_ _0083_ VGND VGND VPWR VPWR _0084_ sky130_fd_sc_hd__inv_2
XFILLER_17_25 VGND VGND VPWR VPWR sky130_fd_sc_hd__decap_4
X_1329_ _0380_ _0382_ _0379_ VGND VGND VPWR VPWR _0423_ sky130_fd_sc_hd__a21oi_1
XPHY_EDGE_ROW_49_Left_101 VGND VGND VPWR VPWR sky130_fd_sc_hd__decap_3
XFILLER_3_125 VGND VGND VPWR VPWR sky130_fd_sc_hd__fill_2
XFILLER_3_169 VGND VGND VPWR VPWR sky130_fd_sc_hd__fill_1
XTAP_TAPCELL_ROW_17_205 VGND VPWR sky130_fd_sc_hd__tapvpwrvgnd_1
XFILLER_30_246 VGND VGND VPWR VPWR sky130_fd_sc_hd__fill_2
X_1680_ _0761_ _0762_ _0763_ VGND VGND VPWR VPWR _0765_ sky130_fd_sc_hd__a21oi_1
X_1114_ net104 net110 _0196_ _0194_ VGND VGND VPWR VPWR _0213_ sky130_fd_sc_hd__a31o_1
XTAP_TAPCELL_ROW_0_106 VGND VPWR sky130_fd_sc_hd__tapvpwrvgnd_1
XTAP_TAPCELL_ROW_48_374 VGND VPWR sky130_fd_sc_hd__tapvpwrvgnd_1
XFILLER_0_72 VGND VGND VPWR VPWR sky130_fd_sc_hd__fill_1
XFILLER_0_83 VGND VGND VPWR VPWR sky130_fd_sc_hd__fill_1
X_1045_ net105 net125 net172 net111 VGND VGND VPWR VPWR _0147_ sky130_fd_sc_hd__and4_1
X_1878_ net72 _0960_ _0962_ VGND VGND VPWR VPWR _0963_ sky130_fd_sc_hd__nor3_1
X_1947_ net68 _0065_ VGND VGND VPWR VPWR _0066_ sky130_fd_sc_hd__and2_1
XFILLER_8_206 VGND VGND VPWR VPWR sky130_fd_sc_hd__fill_2
XFILLER_8_239 VPWR VGND VPWR VGND sky130_ef_sc_hd__decap_12
XFILLER_12_213 VGND VGND VPWR VPWR sky130_fd_sc_hd__decap_6
XTAP_TAPCELL_ROW_22_230 VGND VPWR sky130_fd_sc_hd__tapvpwrvgnd_1
XFILLER_5_39 VGND VGND VPWR VPWR sky130_fd_sc_hd__fill_1
XFILLER_20_290 VGND VGND VPWR VPWR sky130_fd_sc_hd__fill_2
X_1663_ _0746_ _0747_ _0714_ _0716_ VGND VGND VPWR VPWR _0748_ sky130_fd_sc_hd__a211o_1
X_1732_ _0812_ _0813_ _0814_ VGND VGND VPWR VPWR _0815_ sky130_fd_sc_hd__a21oi_1
X_1801_ _0881_ _0882_ VGND VGND VPWR VPWR _0884_ sky130_fd_sc_hd__xnor2_1
XFILLER_7_261 VPWR VGND VPWR VGND sky130_ef_sc_hd__decap_12
X_1594_ net29 net120 net93 VGND VGND VPWR VPWR _0681_ sky130_fd_sc_hd__and3_4
XPHY_EDGE_ROW_7_Right_7 VGND VGND VPWR VPWR sky130_fd_sc_hd__decap_3
XTAP_TAPCELL_ROW_36_311 VGND VPWR sky130_fd_sc_hd__tapvpwrvgnd_1
XFILLER_41_308 VGND VGND VPWR VPWR sky130_fd_sc_hd__fill_1
XFILLER_14_48 VGND VGND VPWR VPWR sky130_fd_sc_hd__decap_6
X_1028_ _0118_ _0129_ VGND VGND VPWR VPWR _0131_ sky130_fd_sc_hd__xnor2_1
XFILLER_30_69 VGND VGND VPWR VPWR sky130_fd_sc_hd__fill_1
XFILLER_30_25 VGND VGND VPWR VPWR sky130_fd_sc_hd__decap_3
XFILLER_39_89 VGND VGND VPWR VPWR sky130_fd_sc_hd__decap_8
XFILLER_39_78 VGND VGND VPWR VPWR sky130_fd_sc_hd__fill_1
XFILLER_4_253 VPWR VGND VPWR VGND sky130_ef_sc_hd__decap_12
XFILLER_20_80 VGND VGND VPWR VPWR sky130_fd_sc_hd__fill_1
XFILLER_35_124 VGND VGND VPWR VPWR sky130_fd_sc_hd__fill_1
X_2000_ _0586_ _0121_ VGND VGND VPWR VPWR _0122_ sky130_fd_sc_hd__xnor2_1
XFILLER_35_157 VGND VGND VPWR VPWR sky130_fd_sc_hd__decap_3
X_1715_ _0797_ _0798_ VGND VGND VPWR VPWR _0799_ sky130_fd_sc_hd__nor2_2
X_1646_ net61 _0730_ _0731_ VGND VGND VPWR VPWR _0732_ sky130_fd_sc_hd__nand3_1
XFILLER_6_82 VGND VGND VPWR VPWR sky130_fd_sc_hd__fill_2
XFILLER_6_60 VGND VGND VPWR VPWR sky130_fd_sc_hd__decap_6
X_1577_ net57 _0663_ _0664_ VGND VGND VPWR VPWR _0665_ sky130_fd_sc_hd__or3_4
Xrebuffer21 _0676_ VGND VGND VPWR VPWR net146 sky130_fd_sc_hd__buf_1
Xrebuffer32 _0362_ VGND VGND VPWR VPWR net157 sky130_fd_sc_hd__buf_1
Xrebuffer43 net90 VGND VGND VPWR VPWR net168 sky130_fd_sc_hd__buf_1
Xrebuffer10 net92 VGND VGND VPWR VPWR net135 sky130_fd_sc_hd__dlymetal6s2s_1
XFILLER_41_57 VGND VGND VPWR VPWR sky130_fd_sc_hd__decap_8
XFILLER_1_223 VGND VGND VPWR VPWR sky130_fd_sc_hd__fill_1
XFILLER_17_113 VPWR VGND VPWR VGND sky130_ef_sc_hd__decap_12
XFILLER_32_149 VPWR VGND VPWR VGND sky130_ef_sc_hd__decap_12
XFILLER_32_116 VPWR VGND VPWR VGND sky130_ef_sc_hd__decap_12
X_1500_ net26 net120 net93 VGND VGND VPWR VPWR _0590_ sky130_fd_sc_hd__and3_4
X_1431_ net24 net121 net158 VGND VGND VPWR VPWR _0523_ sky130_fd_sc_hd__and3_1
X_1293_ net167 net15 net135 VGND VGND VPWR VPWR _0388_ sky130_fd_sc_hd__o21a_1
X_1362_ _0453_ _0454_ _0384_ _0386_ VGND VGND VPWR VPWR _0456_ sky130_fd_sc_hd__o211a_1
X_1629_ net120 net95 net30 VGND VGND VPWR VPWR _0715_ sky130_fd_sc_hd__a21oi_1
X_1980_ _0099_ _0100_ VGND VGND VPWR VPWR _0101_ sky130_fd_sc_hd__nor2_1
Xrebuffer1 _0053_ VGND VGND VPWR VPWR net126 sky130_fd_sc_hd__buf_6
X_1276_ _0370_ _0371_ VGND VGND VPWR VPWR _0372_ sky130_fd_sc_hd__and2_4
X_1414_ _0284_ _0373_ _0331_ _0415_ _0462_ VGND VGND VPWR VPWR _0507_ sky130_fd_sc_hd__a32oi_2
X_1345_ net72 _0437_ _0438_ VGND VGND VPWR VPWR _0439_ sky130_fd_sc_hd__nor3_1
XFILLER_51_277 VGND VGND VPWR VPWR sky130_fd_sc_hd__decap_3
XFILLER_51_233 VGND VGND VPWR VPWR sky130_fd_sc_hd__fill_1
XFILLER_36_241 VGND VGND VPWR VPWR sky130_fd_sc_hd__decap_4
Xfanout121 net123 VGND VGND VPWR VPWR net121 sky130_fd_sc_hd__buf_2
Xfanout110 net16 VGND VGND VPWR VPWR net110 sky130_fd_sc_hd__buf_2
XTAP_TAPCELL_ROW_6_145 VGND VPWR sky130_fd_sc_hd__tapvpwrvgnd_1
XFILLER_47_67 VPWR VGND VPWR VGND sky130_ef_sc_hd__decap_12
XTAP_TAPCELL_ROW_29_269 VGND VPWR sky130_fd_sc_hd__tapvpwrvgnd_1
XFILLER_27_252 VPWR VGND VPWR VGND sky130_ef_sc_hd__decap_12
XFILLER_42_244 VGND VGND VPWR VPWR sky130_fd_sc_hd__decap_8
XFILLER_10_141 VGND VGND VPWR VPWR sky130_fd_sc_hd__decap_8
XFILLER_12_81 VGND VGND VPWR VPWR sky130_fd_sc_hd__decap_3
X_1130_ _0226_ _0227_ _0228_ VGND VGND VPWR VPWR _0229_ sky130_fd_sc_hd__nor3_1
XFILLER_33_255 VPWR VGND VPWR VGND sky130_ef_sc_hd__decap_12
XFILLER_33_200 VPWR VGND VPWR VGND sky130_ef_sc_hd__decap_12
X_1061_ _0160_ _0161_ net124 net110 VGND VGND VPWR VPWR _0162_ sky130_fd_sc_hd__and4bb_1
XFILLER_33_299 VGND VGND VPWR VPWR sky130_fd_sc_hd__decap_6
X_1894_ _0979_ _0978_ VGND VGND VPWR VPWR _0980_ sky130_fd_sc_hd__and2b_1
X_1963_ _0041_ _0082_ VGND VGND VPWR VPWR _0083_ sky130_fd_sc_hd__xor2_1
XTAP_TAPCELL_ROW_3_126 VGND VPWR sky130_fd_sc_hd__tapvpwrvgnd_1
X_1328_ net21 net84 _0422_ net88 VGND VGND VPWR VPWR _0012_ sky130_fd_sc_hd__o211a_1
X_1259_ _0351_ _0352_ net70 VGND VGND VPWR VPWR _0355_ sky130_fd_sc_hd__o21ai_1
XFILLER_24_277 VGND VGND VPWR VPWR sky130_fd_sc_hd__decap_3
XFILLER_15_244 VPWR VGND VPWR VGND sky130_ef_sc_hd__decap_12
XTAP_TAPCELL_ROW_17_206 VGND VPWR sky130_fd_sc_hd__tapvpwrvgnd_1
XTAP_TAPCELL_ROW_25_250 VGND VPWR sky130_fd_sc_hd__tapvpwrvgnd_1
XTAP_TAPCELL_ROW_48_375 VGND VPWR sky130_fd_sc_hd__tapvpwrvgnd_1
XFILLER_0_51 VGND VGND VPWR VPWR sky130_fd_sc_hd__fill_1
XTAP_TAPCELL_ROW_0_107 VGND VPWR sky130_fd_sc_hd__tapvpwrvgnd_1
X_1113_ net78 _0211_ _0212_ net86 VGND VGND VPWR VPWR _0007_ sky130_fd_sc_hd__o211a_1
XFILLER_17_3 VGND VGND VPWR VPWR sky130_fd_sc_hd__fill_1
X_1044_ net105 net172 net111 net125 VGND VGND VPWR VPWR _0146_ sky130_fd_sc_hd__a22o_1
X_1877_ net39 _0262_ VGND VGND VPWR VPWR _0962_ sky130_fd_sc_hd__nor2_1
X_1946_ _0062_ _0063_ VGND VGND VPWR VPWR _0065_ sky130_fd_sc_hd__xor2_1
XTAP_TAPCELL_ROW_22_231 VGND VPWR sky130_fd_sc_hd__tapvpwrvgnd_1
X_1800_ _0881_ _0882_ VGND VGND VPWR VPWR _0883_ sky130_fd_sc_hd__nand2_1
X_1662_ _0743_ _0744_ net178 VGND VGND VPWR VPWR _0747_ sky130_fd_sc_hd__o21ai_1
X_1731_ net66 _0781_ _0782_ VGND VGND VPWR VPWR _0814_ sky130_fd_sc_hd__a21o_1
XFILLER_7_273 VGND VGND VPWR VPWR sky130_fd_sc_hd__decap_6
X_1593_ net28 net83 _0679_ _0680_ net86 VGND VGND VPWR VPWR _0019_ sky130_fd_sc_hd__o221a_1
XTAP_TAPCELL_ROW_36_312 VGND VPWR sky130_fd_sc_hd__tapvpwrvgnd_1
X_1027_ _0097_ _0108_ _0129_ VGND VGND VPWR VPWR _0130_ sky130_fd_sc_hd__or3_1
X_1929_ _0047_ VGND VGND VPWR VPWR _0048_ sky130_fd_sc_hd__inv_2
XFILLER_39_68 VGND VGND VPWR VPWR sky130_fd_sc_hd__fill_1
XFILLER_39_57 VGND VGND VPWR VPWR sky130_fd_sc_hd__decap_6
XFILLER_29_111 VGND VGND VPWR VPWR sky130_fd_sc_hd__fill_1
XFILLER_29_100 VGND VGND VPWR VPWR sky130_fd_sc_hd__fill_1
XFILLER_4_265 VPWR VGND VPWR VGND sky130_ef_sc_hd__decap_12
XFILLER_50_139 VGND VGND VPWR VPWR sky130_fd_sc_hd__fill_1
XFILLER_43_180 VGND VGND VPWR VPWR sky130_fd_sc_hd__fill_1
X_1714_ _0794_ _0795_ _0796_ VGND VGND VPWR VPWR _0798_ sky130_fd_sc_hd__a21oi_1
X_1645_ _0727_ _0728_ _0729_ VGND VGND VPWR VPWR _0731_ sky130_fd_sc_hd__nand3_1
X_1576_ _0661_ _0660_ _0662_ VGND VGND VPWR VPWR _0664_ sky130_fd_sc_hd__and3_1
Xrebuffer11 net170 VGND VGND VPWR VPWR net136 sky130_fd_sc_hd__dlymetal6s2s_1
Xrebuffer22 _0673_ VGND VGND VPWR VPWR net147 sky130_fd_sc_hd__dlymetal6s2s_1
Xrebuffer55 _0603_ VGND VGND VPWR VPWR net180 sky130_fd_sc_hd__buf_1
XFILLER_26_169 VGND VGND VPWR VPWR sky130_fd_sc_hd__decap_6
XFILLER_1_279 VGND VGND VPWR VPWR sky130_fd_sc_hd__fill_1
XFILLER_17_147 VGND VGND VPWR VPWR sky130_fd_sc_hd__decap_8
XFILLER_32_128 VPWR VGND VPWR VGND sky130_ef_sc_hd__decap_12
XFILLER_15_92 VPWR VGND VPWR VGND sky130_ef_sc_hd__decap_12
X_1430_ _0514_ _0521_ VGND VGND VPWR VPWR _0522_ sky130_fd_sc_hd__xor2_1
X_1292_ _0377_ _0385_ VGND VGND VPWR VPWR _0387_ sky130_fd_sc_hd__xnor2_1
X_1361_ _0384_ _0386_ _0453_ net145 VGND VGND VPWR VPWR _0455_ sky130_fd_sc_hd__a211oi_4
XFILLER_23_106 VGND VGND VPWR VPWR sky130_fd_sc_hd__fill_1
XFILLER_31_172 VGND VGND VPWR VPWR sky130_fd_sc_hd__fill_1
X_1628_ net30 net120 net95 VGND VGND VPWR VPWR _0714_ sky130_fd_sc_hd__and3_1
X_1559_ _0645_ _0646_ _0611_ VGND VGND VPWR VPWR _0648_ sky130_fd_sc_hd__o21ai_1
XFILLER_10_301 VGND VGND VPWR VPWR sky130_fd_sc_hd__decap_6
XFILLER_14_139 VGND VGND VPWR VPWR sky130_fd_sc_hd__fill_1
XFILLER_9_143 VGND VGND VPWR VPWR sky130_fd_sc_hd__fill_1
Xrebuffer2 _0389_ VGND VGND VPWR VPWR net127 sky130_fd_sc_hd__buf_4
X_1413_ _0457_ _0504_ VGND VGND VPWR VPWR _0506_ sky130_fd_sc_hd__xnor2_1
XFILLER_36_253 VPWR VGND VPWR VGND sky130_ef_sc_hd__decap_12
X_1275_ _0369_ _0368_ _0322_ net55 VGND VGND VPWR VPWR _0371_ sky130_fd_sc_hd__a211o_1
X_1344_ net119 net169 net22 VGND VGND VPWR VPWR _0438_ sky130_fd_sc_hd__a21oi_1
XFILLER_51_223 VGND VGND VPWR VPWR sky130_fd_sc_hd__fill_1
Xfanout122 net123 VGND VGND VPWR VPWR net122 sky130_fd_sc_hd__buf_1
Xfanout100 net4 VGND VGND VPWR VPWR net100 sky130_fd_sc_hd__buf_2
XTAP_TAPCELL_ROW_6_146 VGND VPWR sky130_fd_sc_hd__tapvpwrvgnd_1
Xfanout111 net15 VGND VGND VPWR VPWR net111 sky130_fd_sc_hd__buf_2
XFILLER_47_79 VGND VGND VPWR VPWR sky130_fd_sc_hd__decap_6
XFILLER_47_57 VGND VGND VPWR VPWR sky130_fd_sc_hd__decap_4
XPHY_EDGE_ROW_29_Right_29 VGND VGND VPWR VPWR sky130_fd_sc_hd__decap_3
XFILLER_27_275 VGND VGND VPWR VPWR sky130_fd_sc_hd__decap_4
XFILLER_27_264 VGND VGND VPWR VPWR sky130_fd_sc_hd__decap_4
XPHY_EDGE_ROW_38_Right_38 VGND VGND VPWR VPWR sky130_fd_sc_hd__decap_3
XFILLER_6_124 VGND VGND VPWR VPWR sky130_fd_sc_hd__fill_1
XFILLER_10_197 VGND VGND VPWR VPWR sky130_fd_sc_hd__fill_1
XPHY_EDGE_ROW_47_Right_47 VGND VGND VPWR VPWR sky130_fd_sc_hd__decap_3
X_1060_ net102 net165 net111 net104 VGND VGND VPWR VPWR _0161_ sky130_fd_sc_hd__a22oi_1
XPHY_EDGE_ROW_25_Left_77 VGND VGND VPWR VPWR sky130_fd_sc_hd__decap_3
XFILLER_33_267 VPWR VGND VPWR VGND sky130_ef_sc_hd__decap_12
XFILLER_33_212 VPWR VGND VPWR VGND sky130_ef_sc_hd__decap_12
X_1962_ _0079_ _0080_ VGND VGND VPWR VPWR _0082_ sky130_fd_sc_hd__xnor2_1
X_1893_ net63 _0945_ _0944_ VGND VGND VPWR VPWR _0979_ sky130_fd_sc_hd__a21oi_1
XTAP_TAPCELL_ROW_11_170 VGND VPWR sky130_fd_sc_hd__tapvpwrvgnd_1
XTAP_TAPCELL_ROW_3_127 VGND VPWR sky130_fd_sc_hd__tapvpwrvgnd_1
X_1189_ net49 net84 VGND VGND VPWR VPWR _0287_ sky130_fd_sc_hd__or2_1
X_1327_ _0417_ _0420_ _0421_ VGND VGND VPWR VPWR _0422_ sky130_fd_sc_hd__o21ai_1
X_1258_ _0351_ net70 _0352_ VGND VGND VPWR VPWR _0354_ sky130_fd_sc_hd__or3_4
XFILLER_24_201 VGND VGND VPWR VPWR sky130_fd_sc_hd__fill_1
XFILLER_33_15 VGND VGND VPWR VPWR sky130_fd_sc_hd__decap_4
XFILLER_15_256 VPWR VGND VPWR VGND sky130_ef_sc_hd__decap_12
XTAP_TAPCELL_ROW_17_207 VGND VPWR sky130_fd_sc_hd__tapvpwrvgnd_1
XTAP_TAPCELL_ROW_25_251 VGND VPWR sky130_fd_sc_hd__tapvpwrvgnd_1
XFILLER_31_6 VPWR VGND VPWR VGND sky130_ef_sc_hd__decap_12
XTAP_TAPCELL_ROW_48_376 VGND VPWR sky130_fd_sc_hd__tapvpwrvgnd_1
XTAP_TAPCELL_ROW_0_108 VGND VPWR sky130_fd_sc_hd__tapvpwrvgnd_1
X_1112_ net47 net82 VGND VGND VPWR VPWR _0212_ sky130_fd_sc_hd__or2_1
X_1043_ _0142_ _0143_ VGND VGND VPWR VPWR _0145_ sky130_fd_sc_hd__xor2_1
X_1945_ _0062_ _0063_ VGND VGND VPWR VPWR _0064_ sky130_fd_sc_hd__and2_1
XFILLER_21_259 VGND VGND VPWR VPWR sky130_fd_sc_hd__fill_1
X_1876_ net39 net119 net158 VGND VGND VPWR VPWR _0960_ sky130_fd_sc_hd__and3_1
XFILLER_28_26 VGND VGND VPWR VPWR sky130_fd_sc_hd__fill_2
XFILLER_44_14 VGND VGND VPWR VPWR sky130_fd_sc_hd__decap_8
XFILLER_12_237 VPWR VGND VPWR VGND sky130_ef_sc_hd__decap_12
XTAP_TAPCELL_ROW_22_232 VGND VPWR sky130_fd_sc_hd__tapvpwrvgnd_1
XTAP_TAPCELL_ROW_45_357 VGND VPWR sky130_fd_sc_hd__tapvpwrvgnd_1
X_1661_ net178 _0743_ _0744_ VGND VGND VPWR VPWR _0746_ sky130_fd_sc_hd__or3_1
X_1730_ _0809_ _0811_ net69 VGND VGND VPWR VPWR _0813_ sky130_fd_sc_hd__a21o_1
X_1592_ _0677_ _0678_ net81 VGND VGND VPWR VPWR _0680_ sky130_fd_sc_hd__a21o_1
XFILLER_11_281 VPWR VGND VPWR VGND sky130_ef_sc_hd__decap_12
XFILLER_38_112 VPWR VGND VPWR VGND sky130_ef_sc_hd__decap_12
XFILLER_38_189 VGND VGND VPWR VPWR sky130_fd_sc_hd__decap_6
XPHY_EDGE_ROW_28_Left_80 VGND VGND VPWR VPWR sky130_fd_sc_hd__decap_3
X_1026_ _0972_ _0983_ VGND VGND VPWR VPWR _0129_ sky130_fd_sc_hd__nor2_1
X_1859_ _0943_ _0942_ VGND VGND VPWR VPWR _0944_ sky130_fd_sc_hd__and2b_1
X_1928_ _0044_ _0046_ VGND VGND VPWR VPWR _0047_ sky130_fd_sc_hd__and2_1
XPHY_EDGE_ROW_12_Left_64 VGND VGND VPWR VPWR sky130_fd_sc_hd__decap_3
XFILLER_39_47 VGND VGND VPWR VPWR sky130_fd_sc_hd__fill_1
XFILLER_29_178 VPWR VGND VPWR VGND sky130_ef_sc_hd__decap_12
XFILLER_29_167 VGND VGND VPWR VPWR sky130_fd_sc_hd__fill_1
XFILLER_4_233 VPWR VGND VPWR VGND sky130_ef_sc_hd__decap_12
XFILLER_4_277 VPWR VGND VPWR VGND sky130_ef_sc_hd__decap_12
Xhold80 net33 VGND VGND VPWR VPWR net205 sky130_fd_sc_hd__dlygate4sd3_1
X_1713_ _0794_ _0795_ _0796_ VGND VGND VPWR VPWR _0797_ sky130_fd_sc_hd__and3_1
X_1644_ _0728_ _0727_ _0729_ VGND VGND VPWR VPWR _0730_ sky130_fd_sc_hd__a21o_1
X_1575_ net193 _0661_ _0662_ VGND VGND VPWR VPWR _0663_ sky130_fd_sc_hd__a21oi_1
Xrebuffer45 _0623_ VGND VGND VPWR VPWR net170 sky130_fd_sc_hd__dlymetal6s2s_1
Xrebuffer12 net136 VGND VGND VPWR VPWR net137 sky130_fd_sc_hd__dlymetal6s4s_1
Xrebuffer34 _0054_ VGND VGND VPWR VPWR net159 sky130_fd_sc_hd__clkbuf_1
X_1009_ net87 net196 VGND VGND VPWR VPWR _0001_ sky130_fd_sc_hd__and2_1
XFILLER_49_218 VGND VGND VPWR VPWR sky130_fd_sc_hd__fill_1
XFILLER_1_225 VPWR VGND VPWR VGND sky130_ef_sc_hd__decap_12
XFILLER_17_137 VGND VGND VPWR VPWR sky130_fd_sc_hd__fill_2
XFILLER_40_184 VGND VGND VPWR VPWR sky130_fd_sc_hd__decap_3
XFILLER_25_181 VGND VGND VPWR VPWR sky130_fd_sc_hd__fill_1
X_1360_ _0452_ _0451_ _0402_ _0405_ VGND VGND VPWR VPWR _0454_ sky130_fd_sc_hd__o211a_1
X_1291_ _0377_ _0385_ VGND VGND VPWR VPWR _0386_ sky130_fd_sc_hd__nand2b_1
XFILLER_31_195 VGND VGND VPWR VPWR sky130_fd_sc_hd__fill_1
X_1627_ net81 _0712_ _0713_ net87 VGND VGND VPWR VPWR _0020_ sky130_fd_sc_hd__o211a_1
X_1558_ _0611_ _0645_ _0646_ VGND VGND VPWR VPWR _0647_ sky130_fd_sc_hd__nor3_2
X_1489_ _0542_ _0578_ VGND VGND VPWR VPWR _0580_ sky130_fd_sc_hd__xnor2_2
XFILLER_7_3 VPWR VGND VPWR VGND sky130_ef_sc_hd__decap_12
XFILLER_45_221 VGND VGND VPWR VPWR sky130_fd_sc_hd__decap_3
XFILLER_42_91 VGND VGND VPWR VPWR sky130_fd_sc_hd__fill_1
Xrebuffer3 _0389_ VGND VGND VPWR VPWR net128 sky130_fd_sc_hd__dlygate4sd1_1
XFILLER_3_30 VGND VGND VPWR VPWR sky130_fd_sc_hd__fill_2
X_1412_ _0457_ _0504_ VGND VGND VPWR VPWR _0505_ sky130_fd_sc_hd__nand2_1
X_1343_ net22 net118 net90 VGND VGND VPWR VPWR _0437_ sky130_fd_sc_hd__and3_4
XFILLER_36_265 VPWR VGND VPWR VGND sky130_ef_sc_hd__decap_12
XFILLER_3_85 VPWR VGND VPWR VGND sky130_ef_sc_hd__decap_12
X_1274_ _0322_ net55 _0368_ _0369_ VGND VGND VPWR VPWR _0370_ sky130_fd_sc_hd__o211ai_2
XTAP_TAPCELL_ROW_14_190 VGND VPWR sky130_fd_sc_hd__tapvpwrvgnd_1
Xfanout123 net12 VGND VGND VPWR VPWR net123 sky130_fd_sc_hd__clkbuf_4
XTAP_TAPCELL_ROW_6_147 VGND VPWR sky130_fd_sc_hd__tapvpwrvgnd_1
Xfanout101 net4 VGND VGND VPWR VPWR net101 sky130_fd_sc_hd__dlymetal6s2s_1
Xfanout112 net113 VGND VGND VPWR VPWR net112 sky130_fd_sc_hd__buf_8
XFILLER_27_232 VGND VGND VPWR VPWR sky130_fd_sc_hd__fill_2
XFILLER_6_114 VGND VGND VPWR VPWR sky130_fd_sc_hd__fill_1
XFILLER_12_61 VPWR VGND VPWR VGND sky130_ef_sc_hd__decap_12
XPHY_EDGE_ROW_0_Left_52 VGND VGND VPWR VPWR sky130_fd_sc_hd__decap_3
XFILLER_33_279 VGND VGND VPWR VPWR sky130_fd_sc_hd__fill_1
X_1892_ net56 _0977_ VGND VGND VPWR VPWR _0978_ sky130_fd_sc_hd__xnor2_1
X_1961_ _0080_ _0079_ VGND VGND VPWR VPWR _0081_ sky130_fd_sc_hd__and2b_1
XFILLER_5_191 VGND VGND VPWR VPWR sky130_fd_sc_hd__decap_4
XTAP_TAPCELL_ROW_11_171 VGND VPWR sky130_fd_sc_hd__tapvpwrvgnd_1
XTAP_TAPCELL_ROW_3_128 VGND VPWR sky130_fd_sc_hd__tapvpwrvgnd_1
X_1326_ _0417_ _0420_ net79 VGND VGND VPWR VPWR _0421_ sky130_fd_sc_hd__a21oi_1
X_1188_ _0284_ _0285_ VGND VGND VPWR VPWR _0286_ sky130_fd_sc_hd__nor2_1
X_1257_ net70 _0351_ _0352_ VGND VGND VPWR VPWR _0353_ sky130_fd_sc_hd__nor3_1
XFILLER_33_49 VGND VGND VPWR VPWR sky130_fd_sc_hd__decap_3
XTAP_TAPCELL_ROW_34_296 VGND VPWR sky130_fd_sc_hd__tapvpwrvgnd_1
XFILLER_33_27 VGND VGND VPWR VPWR sky130_fd_sc_hd__decap_4
XPHY_EDGE_ROW_42_Left_94 VGND VGND VPWR VPWR sky130_fd_sc_hd__decap_3
XFILLER_47_305 VGND VGND VPWR VPWR sky130_fd_sc_hd__decap_4
XFILLER_15_268 VPWR VGND VPWR VGND sky130_ef_sc_hd__decap_12
XTAP_TAPCELL_ROW_48_377 VGND VPWR sky130_fd_sc_hd__tapvpwrvgnd_1
XTAP_TAPCELL_ROW_0_109 VGND VPWR sky130_fd_sc_hd__tapvpwrvgnd_1
X_1111_ _0181_ _0209_ VGND VGND VPWR VPWR _0211_ sky130_fd_sc_hd__xnor2_1
X_1042_ _0142_ _0143_ VGND VGND VPWR VPWR _0144_ sky130_fd_sc_hd__nand2_1
X_1875_ net80 _0958_ _0959_ net89 VGND VGND VPWR VPWR _0028_ sky130_fd_sc_hd__o211a_1
XFILLER_9_73 VPWR VGND VPWR VGND sky130_ef_sc_hd__decap_12
XFILLER_21_205 VGND VGND VPWR VPWR sky130_fd_sc_hd__fill_2
X_1944_ _0988_ _0990_ VGND VGND VPWR VPWR _0063_ sky130_fd_sc_hd__or2_1
X_1309_ _0387_ _0402_ _0403_ VGND VGND VPWR VPWR _0404_ sky130_fd_sc_hd__and3_1
XFILLER_44_37 VGND VGND VPWR VPWR sky130_fd_sc_hd__decap_3
XFILLER_12_249 VGND VGND VPWR VPWR sky130_fd_sc_hd__decap_3
XTAP_TAPCELL_ROW_22_233 VGND VPWR sky130_fd_sc_hd__tapvpwrvgnd_1
XFILLER_47_179 VPWR VGND VPWR VGND sky130_ef_sc_hd__decap_12
XFILLER_47_157 VGND VGND VPWR VPWR sky130_fd_sc_hd__fill_1
XTAP_TAPCELL_ROW_45_358 VGND VPWR sky130_fd_sc_hd__tapvpwrvgnd_1
XFILLER_35_308 VGND VGND VPWR VPWR sky130_fd_sc_hd__fill_1
XFILLER_11_293 VPWR VGND VPWR VGND sky130_ef_sc_hd__decap_12
X_1660_ net73 _0743_ _0744_ VGND VGND VPWR VPWR _0745_ sky130_fd_sc_hd__nor3_1
XFILLER_50_80 VGND VGND VPWR VPWR sky130_fd_sc_hd__decap_4
X_1591_ _0677_ _0678_ VGND VGND VPWR VPWR _0679_ sky130_fd_sc_hd__nor2_1
XFILLER_38_135 VGND VGND VPWR VPWR sky130_fd_sc_hd__fill_2
XFILLER_38_124 VGND VGND VPWR VPWR sky130_fd_sc_hd__decap_8
XFILLER_22_3 VGND VGND VPWR VPWR sky130_fd_sc_hd__fill_1
XFILLER_14_29 VGND VGND VPWR VPWR sky130_fd_sc_hd__decap_6
X_1025_ _0097_ _0108_ VGND VGND VPWR VPWR _0118_ sky130_fd_sc_hd__nor2_1
X_1858_ _0910_ _0911_ _0913_ VGND VGND VPWR VPWR _0943_ sky130_fd_sc_hd__a21oi_1
X_1927_ _0980_ _0043_ VGND VGND VPWR VPWR _0046_ sky130_fd_sc_hd__or2_1
X_1789_ _0865_ _0623_ _0870_ VGND VGND VPWR VPWR _0871_ sky130_fd_sc_hd__a21oi_4
XFILLER_44_149 VGND VGND VPWR VPWR sky130_fd_sc_hd__decap_3
XFILLER_29_113 VGND VGND VPWR VPWR sky130_fd_sc_hd__decap_3
XFILLER_4_289 VPWR VGND VPWR VGND sky130_ef_sc_hd__decap_12
XFILLER_4_245 VGND VGND VPWR VPWR sky130_fd_sc_hd__decap_6
XFILLER_4_223 VGND VGND VPWR VPWR sky130_fd_sc_hd__fill_2
XFILLER_35_149 VGND VGND VPWR VPWR sky130_fd_sc_hd__decap_8
XFILLER_35_138 VGND VGND VPWR VPWR sky130_fd_sc_hd__fill_2
XFILLER_35_116 VGND VGND VPWR VPWR sky130_fd_sc_hd__decap_8
X_1712_ net62 _0759_ _0760_ VGND VGND VPWR VPWR _0796_ sky130_fd_sc_hd__a21bo_1
X_1643_ net57 _0692_ _0693_ VGND VGND VPWR VPWR _0729_ sky130_fd_sc_hd__o21bai_1
X_1574_ net66 _0629_ _0630_ VGND VGND VPWR VPWR _0662_ sky130_fd_sc_hd__a21o_1
XFILLER_6_85 VGND VGND VPWR VPWR sky130_fd_sc_hd__decap_6
Xrebuffer68 _0660_ VGND VGND VPWR VPWR net193 sky130_fd_sc_hd__buf_1
Xrebuffer13 net137 VGND VGND VPWR VPWR net138 sky130_fd_sc_hd__dlymetal6s4s_1
Xrebuffer35 _0632_ VGND VGND VPWR VPWR net160 sky130_fd_sc_hd__buf_1
Xrebuffer46 _0388_ VGND VGND VPWR VPWR net171 sky130_fd_sc_hd__buf_1
XFILLER_41_27 VGND VGND VPWR VPWR sky130_fd_sc_hd__fill_1
X_1008_ net10 net78 VGND VGND VPWR VPWR _0000_ sky130_fd_sc_hd__nor2_1
XFILLER_1_237 VPWR VGND VPWR VGND sky130_ef_sc_hd__decap_12
XFILLER_32_108 VGND VGND VPWR VPWR sky130_fd_sc_hd__fill_2
XFILLER_31_71 VPWR VGND VPWR VGND sky130_ef_sc_hd__decap_12
XFILLER_0_281 VPWR VGND VPWR VGND sky130_ef_sc_hd__decap_12
X_1290_ _0378_ _0383_ VGND VGND VPWR VPWR _0385_ sky130_fd_sc_hd__xnor2_1
X_1626_ net29 net83 VGND VGND VPWR VPWR _0713_ sky130_fd_sc_hd__or2_1
XFILLER_11_19 VGND VGND VPWR VPWR sky130_fd_sc_hd__fill_2
X_1557_ _0642_ _0643_ _0644_ VGND VGND VPWR VPWR _0646_ sky130_fd_sc_hd__a21oi_1
X_1488_ _0542_ _0578_ VGND VGND VPWR VPWR _0579_ sky130_fd_sc_hd__and2b_1
XFILLER_36_49 VGND VGND VPWR VPWR sky130_fd_sc_hd__decap_3
XFILLER_6_307 VGND VGND VPWR VPWR sky130_fd_sc_hd__fill_1
XFILLER_22_163 VGND VGND VPWR VPWR sky130_fd_sc_hd__decap_8
Xrebuffer4 _0346_ VGND VGND VPWR VPWR net129 sky130_fd_sc_hd__dlygate4sd1_1
XFILLER_3_97 VPWR VGND VPWR VGND sky130_ef_sc_hd__decap_12
XFILLER_3_53 VGND VGND VPWR VPWR sky130_fd_sc_hd__decap_3
X_1273_ _0366_ _0367_ _0297_ _0299_ VGND VGND VPWR VPWR _0369_ sky130_fd_sc_hd__o211ai_2
X_1342_ _0434_ _0389_ VGND VGND VPWR VPWR _0436_ sky130_fd_sc_hd__xor2_4
X_1411_ _0502_ _0503_ VGND VGND VPWR VPWR _0504_ sky130_fd_sc_hd__nor2_2
XFILLER_36_299 VGND VGND VPWR VPWR sky130_fd_sc_hd__decap_4
XFILLER_36_277 VGND VGND VPWR VPWR sky130_fd_sc_hd__fill_1
XTAP_TAPCELL_ROW_14_191 VGND VPWR sky130_fd_sc_hd__tapvpwrvgnd_1
X_1609_ net57 _0663_ _0664_ VGND VGND VPWR VPWR _0696_ sky130_fd_sc_hd__o21bai_1
Xfanout102 net3 VGND VGND VPWR VPWR net102 sky130_fd_sc_hd__clkbuf_2
Xfanout113 net14 VGND VGND VPWR VPWR net113 sky130_fd_sc_hd__buf_6
Xfanout124 net1 VGND VGND VPWR VPWR net124 sky130_fd_sc_hd__buf_2
XFILLER_42_225 VGND VGND VPWR VPWR sky130_fd_sc_hd__decap_3
XFILLER_42_203 VGND VGND VPWR VPWR sky130_fd_sc_hd__decap_8
XFILLER_10_166 VGND VGND VPWR VPWR sky130_fd_sc_hd__fill_1
XFILLER_12_73 VGND VGND VPWR VPWR sky130_fd_sc_hd__decap_8
X_1891_ _0974_ _0975_ VGND VGND VPWR VPWR _0977_ sky130_fd_sc_hd__xnor2_1
X_1960_ net63 _0038_ _0037_ VGND VGND VPWR VPWR _0080_ sky130_fd_sc_hd__a21oi_1
XTAP_TAPCELL_ROW_11_172 VGND VPWR sky130_fd_sc_hd__tapvpwrvgnd_1
XTAP_TAPCELL_ROW_3_129 VGND VPWR sky130_fd_sc_hd__tapvpwrvgnd_1
X_1325_ _0418_ _0419_ VGND VGND VPWR VPWR _0420_ sky130_fd_sc_hd__nand2_1
X_1256_ net118 net168 net51 VGND VGND VPWR VPWR _0352_ sky130_fd_sc_hd__a21oi_1
X_1187_ _0244_ _0283_ VGND VGND VPWR VPWR _0285_ sky130_fd_sc_hd__and2_1
XTAP_TAPCELL_ROW_34_297 VGND VPWR sky130_fd_sc_hd__tapvpwrvgnd_1
XFILLER_32_291 VGND VGND VPWR VPWR sky130_fd_sc_hd__fill_1
X_1110_ _0207_ _0179_ _0180_ _0208_ VGND VGND VPWR VPWR _0210_ sky130_fd_sc_hd__and4bb_1
XTAP_TAPCELL_ROW_48_378 VGND VPWR sky130_fd_sc_hd__tapvpwrvgnd_1
XFILLER_0_98 VPWR VGND VPWR VGND sky130_ef_sc_hd__decap_12
X_1041_ _0087_ _0097_ VGND VGND VPWR VPWR _0143_ sky130_fd_sc_hd__or2_1
X_1874_ net38 net85 VGND VGND VPWR VPWR _0959_ sky130_fd_sc_hd__or2_1
XFILLER_9_85 VPWR VGND VPWR VGND sky130_ef_sc_hd__decap_12
X_1943_ _0060_ _0061_ VGND VGND VPWR VPWR _0062_ sky130_fd_sc_hd__nor2_1
X_1239_ _0294_ _0295_ _0292_ VGND VGND VPWR VPWR _0335_ sky130_fd_sc_hd__a21oi_1
X_1308_ _0399_ _0400_ _0401_ VGND VGND VPWR VPWR _0403_ sky130_fd_sc_hd__a21o_1
XFILLER_44_27 VGND VGND VPWR VPWR sky130_fd_sc_hd__fill_1
XTAP_TAPCELL_ROW_22_234 VGND VPWR sky130_fd_sc_hd__tapvpwrvgnd_1
XFILLER_47_169 VGND VGND VPWR VPWR sky130_fd_sc_hd__decap_6
XTAP_TAPCELL_ROW_45_359 VGND VPWR sky130_fd_sc_hd__tapvpwrvgnd_1
X_1590_ net137 _0648_ _0647_ VGND VGND VPWR VPWR _0678_ sky130_fd_sc_hd__a21o_1
X_1024_ net105 net115 _0076_ _0087_ VGND VGND VPWR VPWR _0108_ sky130_fd_sc_hd__o2bb2a_1
X_1788_ _0860_ _0867_ _0866_ _0869_ VGND VGND VPWR VPWR _0870_ sky130_fd_sc_hd__a211o_1
X_1857_ _0588_ _0940_ VGND VGND VPWR VPWR _0942_ sky130_fd_sc_hd__xnor2_1
XFILLER_30_29 VPWR VGND VPWR VGND sky130_ef_sc_hd__decap_12
X_1926_ _0980_ _0043_ VGND VGND VPWR VPWR _0044_ sky130_fd_sc_hd__nand2_1
XFILLER_29_169 VGND VGND VPWR VPWR sky130_fd_sc_hd__decap_3
XFILLER_29_147 VPWR VGND VPWR VGND sky130_ef_sc_hd__decap_12
XTAP_TAPCELL_ROW_50_384 VGND VPWR sky130_fd_sc_hd__tapvpwrvgnd_1
Xhold71 rst_prev VGND VGND VPWR VPWR net196 sky130_fd_sc_hd__dlygate4sd3_1
X_1711_ _0792_ _0793_ net62 VGND VGND VPWR VPWR _0795_ sky130_fd_sc_hd__a21o_1
X_1642_ _0725_ _0726_ net57 VGND VGND VPWR VPWR _0728_ sky130_fd_sc_hd__o21ai_1
X_1573_ _0657_ _0659_ net66 VGND VGND VPWR VPWR _0661_ sky130_fd_sc_hd__a21o_1
Xrebuffer14 _0623_ VGND VGND VPWR VPWR net139 sky130_fd_sc_hd__clkbuf_1
X_1007_ net9 net11 VGND VGND VPWR VPWR _0901_ sky130_fd_sc_hd__nand2_1
Xrebuffer36 _0354_ VGND VGND VPWR VPWR net161 sky130_fd_sc_hd__dlymetal6s2s_1
XFILLER_25_18 VGND VGND VPWR VPWR sky130_fd_sc_hd__fill_1
X_1909_ _0992_ _0994_ VGND VGND VPWR VPWR _0996_ sky130_fd_sc_hd__xnor2_1
XFILLER_1_249 VPWR VGND VPWR VGND sky130_ef_sc_hd__decap_12
XFILLER_31_83 VGND VGND VPWR VPWR sky130_fd_sc_hd__fill_2
Xoutput50 net50 VGND VGND VPWR VPWR acc_out[8] sky130_fd_sc_hd__buf_2
XFILLER_48_253 VPWR VGND VPWR VGND sky130_ef_sc_hd__decap_12
XFILLER_0_293 VPWR VGND VPWR VGND sky130_ef_sc_hd__decap_12
XFILLER_31_164 VGND VGND VPWR VPWR sky130_fd_sc_hd__decap_4
XFILLER_31_153 VGND VGND VPWR VPWR sky130_fd_sc_hd__fill_1
X_1625_ _0707_ _0710_ VGND VGND VPWR VPWR _0712_ sky130_fd_sc_hd__xnor2_1
X_1556_ _0642_ _0643_ _0644_ VGND VGND VPWR VPWR _0645_ sky130_fd_sc_hd__and3_1
XFILLER_39_220 VGND VGND VPWR VPWR sky130_fd_sc_hd__fill_1
X_1487_ _0576_ _0577_ VGND VGND VPWR VPWR _0578_ sky130_fd_sc_hd__nor2_1
X_2039_ clknet_2_3__leaf_clk _0030_ VGND VGND VPWR VPWR net40 sky130_fd_sc_hd__dfxtp_1
XFILLER_22_186 VGND VGND VPWR VPWR sky130_fd_sc_hd__decap_3
XFILLER_45_278 VGND VGND VPWR VPWR sky130_fd_sc_hd__fill_2
XFILLER_9_113 VPWR VGND VPWR VGND sky130_ef_sc_hd__decap_12
X_1410_ _0500_ _0501_ _0453_ _0455_ VGND VGND VPWR VPWR _0503_ sky130_fd_sc_hd__a211oi_2
Xrebuffer5 _0346_ VGND VGND VPWR VPWR net130 sky130_fd_sc_hd__dlymetal6s2s_1
X_1272_ _0297_ _0299_ _0367_ _0366_ VGND VGND VPWR VPWR _0368_ sky130_fd_sc_hd__a211o_1
X_1341_ net127 net143 VGND VGND VPWR VPWR _0435_ sky130_fd_sc_hd__xnor2_4
X_1608_ _0692_ _0693_ net57 VGND VGND VPWR VPWR _0695_ sky130_fd_sc_hd__o21ai_1
X_1539_ _0624_ _0625_ net177 VGND VGND VPWR VPWR _0628_ sky130_fd_sc_hd__o21ai_1
Xfanout114 net115 VGND VGND VPWR VPWR net114 sky130_fd_sc_hd__clkbuf_2
Xfanout103 net3 VGND VGND VPWR VPWR net103 sky130_fd_sc_hd__buf_1
Xfanout125 net1 VGND VGND VPWR VPWR net125 sky130_fd_sc_hd__buf_1
XFILLER_12_41 VGND VGND VPWR VPWR sky130_fd_sc_hd__fill_2
XPHY_EDGE_ROW_16_Right_16 VGND VGND VPWR VPWR sky130_fd_sc_hd__decap_3
XFILLER_18_245 VGND VGND VPWR VPWR sky130_fd_sc_hd__decap_6
XFILLER_41_281 VGND VGND VPWR VPWR sky130_fd_sc_hd__decap_4
X_1890_ _0975_ _0974_ VGND VGND VPWR VPWR _0976_ sky130_fd_sc_hd__and2b_1
XTAP_TAPCELL_ROW_11_173 VGND VPWR sky130_fd_sc_hd__tapvpwrvgnd_1
XPHY_EDGE_ROW_25_Right_25 VGND VGND VPWR VPWR sky130_fd_sc_hd__decap_3
XFILLER_45_3 VPWR VGND VPWR VGND sky130_ef_sc_hd__decap_12
XPHY_EDGE_ROW_34_Right_34 VGND VGND VPWR VPWR sky130_fd_sc_hd__decap_3
X_1324_ _0327_ _0330_ _0372_ VGND VGND VPWR VPWR _0419_ sky130_fd_sc_hd__o21ai_1
X_1186_ _0244_ _0283_ VGND VGND VPWR VPWR _0284_ sky130_fd_sc_hd__nor2_2
X_1255_ net51 net118 net90 VGND VGND VPWR VPWR _0351_ sky130_fd_sc_hd__and3_4
XTAP_TAPCELL_ROW_34_298 VGND VPWR sky130_fd_sc_hd__tapvpwrvgnd_1
XFILLER_24_237 VPWR VGND VPWR VGND sky130_ef_sc_hd__decap_12
XPHY_EDGE_ROW_43_Right_43 VGND VGND VPWR VPWR sky130_fd_sc_hd__decap_3
XFILLER_23_281 VGND VGND VPWR VPWR sky130_fd_sc_hd__fill_1
XFILLER_2_163 VGND VGND VPWR VPWR sky130_fd_sc_hd__decap_6
XFILLER_2_141 VPWR VGND VPWR VGND sky130_ef_sc_hd__decap_12
XFILLER_48_81 VGND VGND VPWR VPWR sky130_fd_sc_hd__decap_3
X_1040_ _0140_ _0141_ VGND VGND VPWR VPWR _0142_ sky130_fd_sc_hd__nor2_1
XFILLER_0_88 VGND VGND VPWR VPWR sky130_fd_sc_hd__decap_3
XFILLER_9_53 VGND VGND VPWR VPWR sky130_fd_sc_hd__decap_3
X_1942_ _0058_ _0059_ net71 VGND VGND VPWR VPWR _0061_ sky130_fd_sc_hd__o21a_1
X_1873_ _0951_ _0956_ VGND VGND VPWR VPWR _0958_ sky130_fd_sc_hd__xnor2_1
XFILLER_9_97 VPWR VGND VPWR VGND sky130_ef_sc_hd__decap_12
XFILLER_28_18 VGND VGND VPWR VPWR sky130_fd_sc_hd__decap_8
XTAP_TAPCELL_ROW_39_324 VGND VPWR sky130_fd_sc_hd__tapvpwrvgnd_1
X_1238_ net202 net84 _0334_ net88 VGND VGND VPWR VPWR _0010_ sky130_fd_sc_hd__o211a_1
X_1169_ _0226_ _0227_ _0228_ VGND VGND VPWR VPWR _0267_ sky130_fd_sc_hd__o21bai_1
X_1307_ _0399_ _0400_ _0401_ VGND VGND VPWR VPWR _0402_ sky130_fd_sc_hd__nand3_2
XTAP_TAPCELL_ROW_22_235 VGND VPWR sky130_fd_sc_hd__tapvpwrvgnd_1
XFILLER_47_126 VPWR VGND VPWR VGND sky130_ef_sc_hd__decap_12
XFILLER_47_104 VGND VGND VPWR VPWR sky130_fd_sc_hd__decap_4
XFILLER_7_200 VPWR VGND VPWR VGND sky130_ef_sc_hd__decap_12
X_1023_ _0076_ _0087_ net105 net115 VGND VGND VPWR VPWR _0097_ sky130_fd_sc_hd__and4bb_1
X_1925_ _0041_ _0042_ VGND VGND VPWR VPWR _0043_ sky130_fd_sc_hd__nor2_1
X_1787_ _0831_ _0770_ _0829_ _0862_ VGND VGND VPWR VPWR _0869_ sky130_fd_sc_hd__and4b_1
X_1856_ _0938_ _0939_ VGND VGND VPWR VPWR _0940_ sky130_fd_sc_hd__nand2b_1
XFILLER_29_126 VGND VGND VPWR VPWR sky130_fd_sc_hd__fill_1
XPHY_EDGE_ROW_2_Right_2 VGND VGND VPWR VPWR sky130_fd_sc_hd__decap_3
XTAP_TAPCELL_ROW_50_385 VGND VPWR sky130_fd_sc_hd__tapvpwrvgnd_1
XFILLER_4_203 VPWR VGND VPWR VGND sky130_ef_sc_hd__decap_12
XFILLER_20_85 VGND VGND VPWR VPWR sky130_fd_sc_hd__fill_2
Xhold72 net31 VGND VGND VPWR VPWR net197 sky130_fd_sc_hd__dlygate4sd3_1
X_1710_ net61 _0792_ _0793_ VGND VGND VPWR VPWR _0794_ sky130_fd_sc_hd__nand3_1
X_1641_ net57 _0725_ _0726_ VGND VGND VPWR VPWR _0727_ sky130_fd_sc_hd__or3_4
X_1572_ _0658_ net64 _0657_ VGND VGND VPWR VPWR _0660_ sky130_fd_sc_hd__or3b_4
XFILLER_6_98 VPWR VGND VPWR VGND sky130_ef_sc_hd__decap_12
XPHY_EDGE_ROW_16_Left_68 VGND VGND VPWR VPWR sky130_fd_sc_hd__decap_3
Xrebuffer48 net174 VGND VGND VPWR VPWR net173 sky130_fd_sc_hd__buf_6
X_1006_ net9 net11 VGND VGND VPWR VPWR _0890_ sky130_fd_sc_hd__and2_2
Xrebuffer37 _0351_ VGND VGND VPWR VPWR net162 sky130_fd_sc_hd__dlygate4sd1_1
XFILLER_19_192 VGND VGND VPWR VPWR sky130_fd_sc_hd__fill_2
X_1839_ _0920_ _0921_ VGND VGND VPWR VPWR _0923_ sky130_fd_sc_hd__and2b_1
X_1908_ _0992_ _0994_ VGND VGND VPWR VPWR _0995_ sky130_fd_sc_hd__and2_1
XFILLER_25_195 VGND VGND VPWR VPWR sky130_fd_sc_hd__fill_2
XFILLER_31_51 VGND VGND VPWR VPWR sky130_fd_sc_hd__fill_1
Xoutput51 net51 VGND VGND VPWR VPWR acc_out[9] sky130_fd_sc_hd__buf_2
Xoutput40 net40 VGND VGND VPWR VPWR acc_out[28] sky130_fd_sc_hd__buf_2
XFILLER_48_265 VPWR VGND VPWR VGND sky130_ef_sc_hd__decap_12
X_1624_ _0710_ _0707_ VGND VGND VPWR VPWR _0711_ sky130_fd_sc_hd__nand2b_1
X_1555_ _0587_ _0607_ _0606_ VGND VGND VPWR VPWR _0644_ sky130_fd_sc_hd__a21bo_1
XFILLER_39_232 VPWR VGND VPWR VGND sky130_ef_sc_hd__decap_12
XFILLER_36_29 VGND VGND VPWR VPWR sky130_fd_sc_hd__fill_2
X_1486_ _0574_ _0575_ _0538_ _0540_ VGND VGND VPWR VPWR _0577_ sky130_fd_sc_hd__a211oi_1
X_2038_ clknet_2_3__leaf_clk _0029_ VGND VGND VPWR VPWR net39 sky130_fd_sc_hd__dfxtp_1
XFILLER_42_72 VGND VGND VPWR VPWR sky130_fd_sc_hd__fill_2
XFILLER_9_125 VGND VGND VPWR VPWR sky130_fd_sc_hd__decap_4
XFILLER_9_169 VGND VGND VPWR VPWR sky130_fd_sc_hd__fill_1
XFILLER_13_154 VGND VGND VPWR VPWR sky130_fd_sc_hd__fill_1
XFILLER_13_187 VGND VGND VPWR VPWR sky130_fd_sc_hd__decap_6
XFILLER_47_7 VPWR VGND VPWR VGND sky130_ef_sc_hd__decap_12
X_1340_ net16 net133 VGND VGND VPWR VPWR _0434_ sky130_fd_sc_hd__nand2_4
Xrebuffer6 net92 VGND VGND VPWR VPWR net131 sky130_fd_sc_hd__dlymetal6s2s_1
XFILLER_36_213 VGND VGND VPWR VPWR sky130_fd_sc_hd__fill_1
X_1271_ _0365_ _0363_ _0318_ _0320_ VGND VGND VPWR VPWR _0367_ sky130_fd_sc_hd__o211a_1
XFILLER_51_238 VGND VGND VPWR VPWR sky130_fd_sc_hd__decap_3
XFILLER_51_205 VGND VGND VPWR VPWR sky130_fd_sc_hd__decap_3
XFILLER_44_290 VPWR VGND VPWR VGND sky130_ef_sc_hd__decap_12
XFILLER_8_191 VGND VGND VPWR VPWR sky130_fd_sc_hd__decap_4
X_1607_ net57 _0692_ _0693_ VGND VGND VPWR VPWR _0694_ sky130_fd_sc_hd__or3_4
X_1538_ net74 _0624_ _0625_ VGND VGND VPWR VPWR _0627_ sky130_fd_sc_hd__or3_4
X_1469_ _0556_ _0557_ net177 VGND VGND VPWR VPWR _0560_ sky130_fd_sc_hd__o21ai_1
Xfanout104 net2 VGND VGND VPWR VPWR net104 sky130_fd_sc_hd__clkbuf_4
Xfanout115 net13 VGND VGND VPWR VPWR net115 sky130_fd_sc_hd__clkbuf_2
XFILLER_27_279 VGND VGND VPWR VPWR sky130_fd_sc_hd__fill_1
XPHY_EDGE_ROW_19_Left_71 VGND VGND VPWR VPWR sky130_fd_sc_hd__decap_3
XFILLER_10_113 VGND VGND VPWR VPWR sky130_fd_sc_hd__decap_6
XFILLER_6_128 VPWR VGND VPWR VGND sky130_ef_sc_hd__decap_12
XFILLER_5_3 VGND VGND VPWR VPWR sky130_fd_sc_hd__decap_6
XFILLER_2_301 VGND VGND VPWR VPWR sky130_fd_sc_hd__decap_6
XFILLER_18_213 VGND VGND VPWR VPWR sky130_fd_sc_hd__decap_4
XFILLER_33_249 VGND VGND VPWR VPWR sky130_fd_sc_hd__fill_2
XTAP_TAPCELL_ROW_28_263 VGND VPWR sky130_fd_sc_hd__tapvpwrvgnd_1
XTAP_TAPCELL_ROW_11_174 VGND VPWR sky130_fd_sc_hd__tapvpwrvgnd_1
X_1323_ _0332_ _0373_ VGND VGND VPWR VPWR _0418_ sky130_fd_sc_hd__nand2b_1
X_1185_ _0249_ _0282_ VGND VGND VPWR VPWR _0283_ sky130_fd_sc_hd__xnor2_1
X_1254_ _0348_ _0349_ VGND VGND VPWR VPWR _0350_ sky130_fd_sc_hd__xor2_2
XTAP_TAPCELL_ROW_34_299 VGND VPWR sky130_fd_sc_hd__tapvpwrvgnd_1
XFILLER_33_19 VGND VGND VPWR VPWR sky130_fd_sc_hd__fill_1
XFILLER_24_249 VGND VGND VPWR VPWR sky130_fd_sc_hd__decap_3
XFILLER_3_109 VGND VGND VPWR VPWR sky130_fd_sc_hd__decap_3
XTAP_TAPCELL_ROW_2_120 VGND VPWR sky130_fd_sc_hd__tapvpwrvgnd_1
XPHY_EDGE_ROW_4_Left_56 VGND VGND VPWR VPWR sky130_fd_sc_hd__decap_3
XFILLER_15_216 VGND VGND VPWR VPWR sky130_fd_sc_hd__decap_8
XFILLER_23_41 VGND VGND VPWR VPWR sky130_fd_sc_hd__fill_1
XFILLER_2_197 VPWR VGND VPWR VGND sky130_ef_sc_hd__decap_12
XFILLER_2_153 VGND VGND VPWR VPWR sky130_fd_sc_hd__decap_6
XFILLER_48_71 VGND VGND VPWR VPWR sky130_fd_sc_hd__fill_1
X_1872_ _0955_ _0953_ _0951_ VGND VGND VPWR VPWR _0957_ sky130_fd_sc_hd__o21ai_1
XTAP_TAPCELL_ROW_16_200 VGND VPWR sky130_fd_sc_hd__tapvpwrvgnd_1
X_1941_ net71 _0058_ _0059_ VGND VGND VPWR VPWR _0060_ sky130_fd_sc_hd__nor3_1
XTAP_TAPCELL_ROW_39_325 VGND VPWR sky130_fd_sc_hd__tapvpwrvgnd_1
X_1306_ _0350_ _0357_ _0356_ VGND VGND VPWR VPWR _0401_ sky130_fd_sc_hd__a21bo_1
XPHY_EDGE_ROW_46_Left_98 VGND VGND VPWR VPWR sky130_fd_sc_hd__decap_3
XFILLER_44_29 VGND VGND VPWR VPWR sky130_fd_sc_hd__decap_8
X_1237_ _0332_ _0333_ net79 VGND VGND VPWR VPWR _0334_ sky130_fd_sc_hd__a21o_1
X_1099_ _0191_ _0192_ _0197_ VGND VGND VPWR VPWR _0199_ sky130_fd_sc_hd__a21o_1
X_1168_ _0262_ _0265_ VGND VGND VPWR VPWR _0266_ sky130_fd_sc_hd__xnor2_2
XFILLER_12_219 VGND VGND VPWR VPWR sky130_fd_sc_hd__fill_1
XFILLER_47_138 VGND VGND VPWR VPWR sky130_fd_sc_hd__decap_4
XFILLER_50_94 VGND VGND VPWR VPWR sky130_fd_sc_hd__decap_3
XFILLER_7_212 VPWR VGND VPWR VGND sky130_ef_sc_hd__decap_12
X_1022_ net42 net117 net103 VGND VGND VPWR VPWR _0087_ sky130_fd_sc_hd__and3_1
X_1855_ _0936_ _0937_ VGND VGND VPWR VPWR _0939_ sky130_fd_sc_hd__nand2_1
X_1924_ _0039_ _0040_ VGND VGND VPWR VPWR _0042_ sky130_fd_sc_hd__and2b_1
X_1786_ _0828_ _0861_ VGND VGND VPWR VPWR _0867_ sky130_fd_sc_hd__nand2_1
XFILLER_29_138 VGND VGND VPWR VPWR sky130_fd_sc_hd__decap_4
XFILLER_37_182 VGND VGND VPWR VPWR sky130_fd_sc_hd__decap_4
XTAP_TAPCELL_ROW_50_386 VGND VPWR sky130_fd_sc_hd__tapvpwrvgnd_1
XFILLER_4_215 VGND VGND VPWR VPWR sky130_fd_sc_hd__decap_8
Xhold73 net32 VGND VGND VPWR VPWR net198 sky130_fd_sc_hd__dlygate4sd3_1
XFILLER_31_303 VGND VGND VPWR VPWR sky130_fd_sc_hd__fill_2
X_1640_ _0723_ _0722_ _0724_ VGND VGND VPWR VPWR _0726_ sky130_fd_sc_hd__and3_1
X_1571_ _0624_ _0626_ _0655_ _0656_ VGND VGND VPWR VPWR _0659_ sky130_fd_sc_hd__o211ai_1
XFILLER_6_33 VGND VGND VPWR VPWR sky130_fd_sc_hd__fill_1
XFILLER_6_11 VGND VGND VPWR VPWR sky130_fd_sc_hd__decap_3
XFILLER_3_281 VPWR VGND VPWR VGND sky130_ef_sc_hd__decap_12
Xrebuffer16 _0436_ VGND VGND VPWR VPWR net141 sky130_fd_sc_hd__dlygate4sd1_1
X_1005_ net10 VGND VGND VPWR VPWR _0879_ sky130_fd_sc_hd__inv_2
XFILLER_34_152 VGND VGND VPWR VPWR sky130_fd_sc_hd__fill_2
XFILLER_34_141 VGND VGND VPWR VPWR sky130_fd_sc_hd__fill_2
Xrebuffer49 net175 VGND VGND VPWR VPWR net174 sky130_fd_sc_hd__clkbuf_1
Xrebuffer38 _0351_ VGND VGND VPWR VPWR net163 sky130_fd_sc_hd__dlygate4sd1_1
X_1838_ _0921_ _0920_ VGND VGND VPWR VPWR _0922_ sky130_fd_sc_hd__and2b_1
XFILLER_41_19 VGND VGND VPWR VPWR sky130_fd_sc_hd__fill_1
X_1907_ _0960_ _0963_ VGND VGND VPWR VPWR _0994_ sky130_fd_sc_hd__or2_1
X_1769_ _0848_ _0849_ _0588_ VGND VGND VPWR VPWR _0851_ sky130_fd_sc_hd__a21o_1
XFILLER_1_207 VPWR VGND VPWR VGND sky130_ef_sc_hd__decap_12
XFILLER_17_108 VGND VGND VPWR VPWR sky130_fd_sc_hd__decap_4
XFILLER_40_111 VGND VGND VPWR VPWR sky130_fd_sc_hd__fill_1
XFILLER_15_20 VGND VGND VPWR VPWR sky130_fd_sc_hd__fill_1
Xoutput30 net30 VGND VGND VPWR VPWR acc_out[19] sky130_fd_sc_hd__buf_2
Xoutput52 net52 VGND VGND VPWR VPWR done sky130_fd_sc_hd__buf_2
XPHY_EDGE_ROW_33_Left_85 VGND VGND VPWR VPWR sky130_fd_sc_hd__decap_3
XFILLER_31_30 VGND VGND VPWR VPWR sky130_fd_sc_hd__decap_8
Xoutput41 net41 VGND VGND VPWR VPWR acc_out[29] sky130_fd_sc_hd__buf_2
XFILLER_48_277 VPWR VGND VPWR VGND sky130_ef_sc_hd__decap_12
XFILLER_16_141 VGND VGND VPWR VPWR sky130_fd_sc_hd__fill_2
XFILLER_31_177 VGND VGND VPWR VPWR sky130_fd_sc_hd__fill_1
X_1623_ net136 _0709_ _0708_ VGND VGND VPWR VPWR _0710_ sky130_fd_sc_hd__a21oi_1
X_1554_ _0640_ _0641_ net56 VGND VGND VPWR VPWR _0643_ sky130_fd_sc_hd__o21ai_1
X_1485_ _0538_ _0540_ _0574_ _0575_ VGND VGND VPWR VPWR _0576_ sky130_fd_sc_hd__o211a_1
.ends
